** sch_path: integration_cell_v1.sch
.subckt integration_cell_v1 AVSS Vbiasn Vbiasp VCM VREFP Vinn Vinp AVDD DVSS rst in_clk serial_out
+ DVDD load_en
*.PININFO AVSS:B Vbiasn:B Vbiasp:B VCM:B VREFP:B Vinn:B Vinp:B AVDD:B DVSS:B rst:B in_clk:B
*+ serial_out:B DVDD:B load_en:B
Xu_clk in_clk CLK1 CLK2 CLK2B CLK_CIC_FROM_GENERATOR rst DVDD DVSS andig_clock
Xu_cic CLK_CIC_FROM_GENERATOR AN_COMPARATOR_VOUT rst DVDD DVSS CIC_Q0 CIC_Q1 CIC_Q2 CIC_Q3 CIC_Q4
+ CIC_Q5 CIC_Q6 CIC_Q7 CIC_Q8 CIC_Q9 CIC_Q10 CIC_Q11 cic_filter
Xu_piso CLK2B load_en rst serial_out DVDD DVSS CIC_Q0 CIC_Q1 CIC_Q2 CIC_Q3 CIC_Q4 CIC_Q5 CIC_Q6
+ CIC_Q7 CIC_Q8 CIC_Q9 CIC_Q10 CIC_Q11 piso_12bit
Xu_analog CORE_Vinp CORE_Vinn AN_VOP AN_VOM CLK1 CLK2 CORE_Vbiasn CORE_Vbiasp CLK2B
+ AN_COMPARATOR_VOUT AVDD AVSS CORE_VCM CORE_VREFP analog_integration_lvs
Xpad_0 Vinp CORE_Vinp AVDD ppolyf_u r_width=40u r_length=10u
Xpad_1 Vbiasp CORE_Vbiasp AVDD ppolyf_u r_width=40u r_length=10u
Xpad_2 VCM CORE_VCM AVDD ppolyf_u r_width=40u r_length=10u
Xpad_3 Vbiasn CORE_Vbiasn AVDD ppolyf_u r_width=40u r_length=10u
Xpad_4 VREFP CORE_VREFP AVDD ppolyf_u r_width=40u r_length=10u
Xpad_5 Vinn CORE_Vinn AVDD ppolyf_u r_width=40u r_length=10u
Dpad_0 CORE_Vinn AVDD diode_pd2nw_06v0 pj=40u area=99.99999p
Dpad_1 DVSS CORE_Vbiasp diode_nd2ps_06v0 pj=40u area=99.99999p
Dpad_2 CORE_Vinp AVDD diode_pd2nw_06v0 pj=40u area=99.99999p
Dpad_3 CORE_VREFP AVDD diode_pd2nw_06v0 pj=40u area=99.99999p
Dpad_4 CORE_VCM AVDD diode_pd2nw_06v0 pj=40u area=99.99999p
Dpad_5 DVSS CORE_Vinn diode_nd2ps_06v0 pj=40u area=99.99999p
Dpad_6 DVSS CORE_VREFP diode_nd2ps_06v0 pj=40u area=99.99999p
Dpad_7 CORE_VCM AVDD diode_pd2nw_06v0 pj=40u area=99.99999p
Dpad_8 DVSS CORE_Vbiasp diode_nd2ps_06v0 pj=40u area=99.99999p
Dpad_9 DVSS CORE_Vbiasn diode_nd2ps_06v0 pj=40u area=99.99999p
Dpad_10 CORE_Vinn AVDD diode_pd2nw_06v0 pj=40u area=99.99999p
Dpad_11 CORE_VCM AVDD diode_pd2nw_06v0 pj=40u area=99.99999p
Dpad_12 CORE_Vbiasn AVDD diode_pd2nw_06v0 pj=40u area=99.99999p
Dpad_13 CORE_Vbiasn AVDD diode_pd2nw_06v0 pj=40u area=99.99999p
Dpad_14 DVSS CORE_VCM diode_nd2ps_06v0 pj=40u area=99.99999p
Dpad_15 DVSS CORE_VREFP diode_nd2ps_06v0 pj=40u area=99.99999p
Dpad_16 CORE_VREFP AVDD diode_pd2nw_06v0 pj=40u area=99.99999p
Dpad_17 CORE_VREFP AVDD diode_pd2nw_06v0 pj=40u area=99.99999p
Dpad_18 CORE_Vbiasp AVDD diode_pd2nw_06v0 pj=40u area=99.99999p
Dpad_19 DVSS CORE_Vbiasn diode_nd2ps_06v0 pj=40u area=99.99999p
Dpad_20 DVSS CORE_Vbiasn diode_nd2ps_06v0 pj=40u area=99.99999p
Dpad_21 DVSS CORE_Vbiasn diode_nd2ps_06v0 pj=40u area=99.99999p
Dpad_22 CORE_Vinp AVDD diode_pd2nw_06v0 pj=40u area=99.99999p
Dpad_23 DVSS CORE_VCM diode_nd2ps_06v0 pj=40u area=99.99999p
Dpad_24 CORE_Vbiasp AVDD diode_pd2nw_06v0 pj=40u area=99.99999p
Dpad_25 DVSS CORE_VCM diode_nd2ps_06v0 pj=40u area=99.99999p
Dpad_26 CORE_VREFP AVDD diode_pd2nw_06v0 pj=40u area=99.99999p
Dpad_27 DVSS CORE_Vbiasp diode_nd2ps_06v0 pj=40u area=99.99999p
Dpad_28 DVSS CORE_Vbiasp diode_nd2ps_06v0 pj=40u area=99.99999p
Dpad_29 CORE_Vinn AVDD diode_pd2nw_06v0 pj=40u area=99.99999p
Dpad_30 CORE_Vbiasp AVDD diode_pd2nw_06v0 pj=40u area=99.99999p
Dpad_31 DVSS CORE_Vinp diode_nd2ps_06v0 pj=40u area=99.99999p
Dpad_32 CORE_VCM AVDD diode_pd2nw_06v0 pj=40u area=99.99999p
Dpad_33 CORE_Vbiasp AVDD diode_pd2nw_06v0 pj=40u area=99.99999p
Dpad_34 DVSS CORE_VCM diode_nd2ps_06v0 pj=40u area=99.99999p
Dpad_35 CORE_Vbiasn AVDD diode_pd2nw_06v0 pj=40u area=99.99999p
Dpad_36 DVSS CORE_Vinp diode_nd2ps_06v0 pj=40u area=99.99999p
Dpad_37 DVSS CORE_Vinn diode_nd2ps_06v0 pj=40u area=99.99999p
Dpad_38 DVSS CORE_Vinn diode_nd2ps_06v0 pj=40u area=99.99999p
Dpad_39 CORE_Vinp AVDD diode_pd2nw_06v0 pj=40u area=99.99999p
Dpad_40 DVSS CORE_VREFP diode_nd2ps_06v0 pj=40u area=99.99999p
Dpad_41 CORE_Vbiasn AVDD diode_pd2nw_06v0 pj=40u area=99.99999p
Dpad_42 DVSS CORE_Vinp diode_nd2ps_06v0 pj=40u area=99.99999p
Dpad_43 CORE_Vinp AVDD diode_pd2nw_06v0 pj=40u area=99.99999p
Dpad_44 DVSS CORE_Vinn diode_nd2ps_06v0 pj=40u area=99.99999p
Dpad_45 DVSS CORE_VREFP diode_nd2ps_06v0 pj=40u area=99.99999p
Dpad_46 DVSS CORE_Vinp diode_nd2ps_06v0 pj=40u area=99.99999p
Dpad_47 CORE_Vinn AVDD diode_pd2nw_06v0 pj=40u area=99.99999p
.ends

* expanding   symbol:  ./andig_clock.sym # of pins=8
** sym_path: andig_clock.sym
** sch_path: andig_clock.sch
.subckt andig_clock in_clk out_clk1 out_clk2 out_clk2B out_clk_cic rst VDD VSS
*.PININFO in_clk:B out_clk1:B out_clk2:B out_clk2B:B out_clk_cic:B rst:B VDD:B VSS:B
XFILLER_0_104 VDD VDD VSS VSS gf180mcu_fd_sc_mcu7t5v0__fillcap_32
XFILLER_0_138 VDD VDD VSS VSS gf180mcu_fd_sc_mcu7t5v0__fillcap_8
XFILLER_0_146 VDD VDD VSS VSS gf180mcu_fd_sc_mcu7t5v0__fillcap_4
XFILLER_0_150 VDD VDD VSS VSS gf180mcu_fd_sc_mcu7t5v0__fill_2
XFILLER_0_2 VDD VDD VSS VSS gf180mcu_fd_sc_mcu7t5v0__fillcap_32
XFILLER_0_36 VDD VDD VSS VSS gf180mcu_fd_sc_mcu7t5v0__fillcap_32
XFILLER_0_70 VDD VDD VSS VSS gf180mcu_fd_sc_mcu7t5v0__fillcap_32
XFILLER_10_115 VDD VDD VSS VSS gf180mcu_fd_sc_mcu7t5v0__fill_1
XFILLER_10_140 VDD VDD VSS VSS gf180mcu_fd_sc_mcu7t5v0__fillcap_8
XFILLER_10_148 VDD VDD VSS VSS gf180mcu_fd_sc_mcu7t5v0__fillcap_4
XFILLER_10_2 VDD VDD VSS VSS gf180mcu_fd_sc_mcu7t5v0__fillcap_32
XFILLER_10_34 VDD VDD VSS VSS gf180mcu_fd_sc_mcu7t5v0__fill_1
XFILLER_10_37 VDD VDD VSS VSS gf180mcu_fd_sc_mcu7t5v0__fillcap_16
XFILLER_10_53 VDD VDD VSS VSS gf180mcu_fd_sc_mcu7t5v0__fillcap_8
XFILLER_10_61 VDD VDD VSS VSS gf180mcu_fd_sc_mcu7t5v0__fillcap_4
XFILLER_10_99 VDD VDD VSS VSS gf180mcu_fd_sc_mcu7t5v0__fill_1
XFILLER_11_104 VDD VDD VSS VSS gf180mcu_fd_sc_mcu7t5v0__fillcap_4
XFILLER_11_122 VDD VDD VSS VSS gf180mcu_fd_sc_mcu7t5v0__fill_2
XFILLER_11_146 VDD VDD VSS VSS gf180mcu_fd_sc_mcu7t5v0__fillcap_4
XFILLER_11_150 VDD VDD VSS VSS gf180mcu_fd_sc_mcu7t5v0__fill_2
XFILLER_11_2 VDD VDD VSS VSS gf180mcu_fd_sc_mcu7t5v0__fillcap_64
XFILLER_11_66 VDD VDD VSS VSS gf180mcu_fd_sc_mcu7t5v0__fillcap_4
XFILLER_11_72 VDD VDD VSS VSS gf180mcu_fd_sc_mcu7t5v0__fillcap_32
XFILLER_12_101 VDD VDD VSS VSS gf180mcu_fd_sc_mcu7t5v0__fillcap_4
XFILLER_12_107 VDD VDD VSS VSS gf180mcu_fd_sc_mcu7t5v0__fillcap_8
XFILLER_12_115 VDD VDD VSS VSS gf180mcu_fd_sc_mcu7t5v0__fill_2
XFILLER_12_117 VDD VDD VSS VSS gf180mcu_fd_sc_mcu7t5v0__fill_1
XFILLER_12_2 VDD VDD VSS VSS gf180mcu_fd_sc_mcu7t5v0__fillcap_32
XFILLER_12_34 VDD VDD VSS VSS gf180mcu_fd_sc_mcu7t5v0__fill_1
XFILLER_12_37 VDD VDD VSS VSS gf180mcu_fd_sc_mcu7t5v0__fillcap_64
XFILLER_13_136 VDD VDD VSS VSS gf180mcu_fd_sc_mcu7t5v0__fillcap_4
XFILLER_13_142 VDD VDD VSS VSS gf180mcu_fd_sc_mcu7t5v0__fillcap_8
XFILLER_13_150 VDD VDD VSS VSS gf180mcu_fd_sc_mcu7t5v0__fill_2
XFILLER_13_2 VDD VDD VSS VSS gf180mcu_fd_sc_mcu7t5v0__fillcap_64
XFILLER_13_66 VDD VDD VSS VSS gf180mcu_fd_sc_mcu7t5v0__fillcap_4
XFILLER_13_72 VDD VDD VSS VSS gf180mcu_fd_sc_mcu7t5v0__fillcap_64
XFILLER_14_101 VDD VDD VSS VSS gf180mcu_fd_sc_mcu7t5v0__fillcap_4
XFILLER_14_107 VDD VDD VSS VSS gf180mcu_fd_sc_mcu7t5v0__fillcap_16
XFILLER_14_123 VDD VDD VSS VSS gf180mcu_fd_sc_mcu7t5v0__fillcap_8
XFILLER_14_131 VDD VDD VSS VSS gf180mcu_fd_sc_mcu7t5v0__fillcap_4
XFILLER_14_135 VDD VDD VSS VSS gf180mcu_fd_sc_mcu7t5v0__fill_1
XFILLER_14_2 VDD VDD VSS VSS gf180mcu_fd_sc_mcu7t5v0__fillcap_32
XFILLER_14_34 VDD VDD VSS VSS gf180mcu_fd_sc_mcu7t5v0__fill_1
XFILLER_14_37 VDD VDD VSS VSS gf180mcu_fd_sc_mcu7t5v0__fillcap_64
XFILLER_15_136 VDD VDD VSS VSS gf180mcu_fd_sc_mcu7t5v0__fillcap_4
XFILLER_15_142 VDD VDD VSS VSS gf180mcu_fd_sc_mcu7t5v0__fillcap_8
XFILLER_15_150 VDD VDD VSS VSS gf180mcu_fd_sc_mcu7t5v0__fill_2
XFILLER_15_2 VDD VDD VSS VSS gf180mcu_fd_sc_mcu7t5v0__fillcap_64
XFILLER_15_66 VDD VDD VSS VSS gf180mcu_fd_sc_mcu7t5v0__fillcap_4
XFILLER_15_72 VDD VDD VSS VSS gf180mcu_fd_sc_mcu7t5v0__fillcap_64
XFILLER_16_104 VDD VDD VSS VSS gf180mcu_fd_sc_mcu7t5v0__fillcap_32
XFILLER_16_138 VDD VDD VSS VSS gf180mcu_fd_sc_mcu7t5v0__fillcap_8
XFILLER_16_146 VDD VDD VSS VSS gf180mcu_fd_sc_mcu7t5v0__fillcap_4
XFILLER_16_150 VDD VDD VSS VSS gf180mcu_fd_sc_mcu7t5v0__fill_2
XFILLER_16_2 VDD VDD VSS VSS gf180mcu_fd_sc_mcu7t5v0__fillcap_32
XFILLER_16_36 VDD VDD VSS VSS gf180mcu_fd_sc_mcu7t5v0__fillcap_32
XFILLER_16_70 VDD VDD VSS VSS gf180mcu_fd_sc_mcu7t5v0__fillcap_32
XFILLER_1_136 VDD VDD VSS VSS gf180mcu_fd_sc_mcu7t5v0__fillcap_4
XFILLER_1_142 VDD VDD VSS VSS gf180mcu_fd_sc_mcu7t5v0__fillcap_8
XFILLER_1_150 VDD VDD VSS VSS gf180mcu_fd_sc_mcu7t5v0__fill_2
XFILLER_1_2 VDD VDD VSS VSS gf180mcu_fd_sc_mcu7t5v0__fillcap_64
XFILLER_1_66 VDD VDD VSS VSS gf180mcu_fd_sc_mcu7t5v0__fillcap_4
XFILLER_1_72 VDD VDD VSS VSS gf180mcu_fd_sc_mcu7t5v0__fillcap_64
XFILLER_2_101 VDD VDD VSS VSS gf180mcu_fd_sc_mcu7t5v0__fillcap_4
XFILLER_2_107 VDD VDD VSS VSS gf180mcu_fd_sc_mcu7t5v0__fillcap_32
XFILLER_2_139 VDD VDD VSS VSS gf180mcu_fd_sc_mcu7t5v0__fillcap_8
XFILLER_2_147 VDD VDD VSS VSS gf180mcu_fd_sc_mcu7t5v0__fillcap_4
XFILLER_2_151 VDD VDD VSS VSS gf180mcu_fd_sc_mcu7t5v0__fill_1
XFILLER_2_2 VDD VDD VSS VSS gf180mcu_fd_sc_mcu7t5v0__fillcap_32
XFILLER_2_34 VDD VDD VSS VSS gf180mcu_fd_sc_mcu7t5v0__fill_1
XFILLER_2_37 VDD VDD VSS VSS gf180mcu_fd_sc_mcu7t5v0__fillcap_64
XFILLER_3_136 VDD VDD VSS VSS gf180mcu_fd_sc_mcu7t5v0__fillcap_4
XFILLER_3_142 VDD VDD VSS VSS gf180mcu_fd_sc_mcu7t5v0__fillcap_8
XFILLER_3_150 VDD VDD VSS VSS gf180mcu_fd_sc_mcu7t5v0__fill_2
XFILLER_3_2 VDD VDD VSS VSS gf180mcu_fd_sc_mcu7t5v0__fillcap_64
XFILLER_3_66 VDD VDD VSS VSS gf180mcu_fd_sc_mcu7t5v0__fillcap_4
XFILLER_3_72 VDD VDD VSS VSS gf180mcu_fd_sc_mcu7t5v0__fillcap_64
XFILLER_4_102 VDD VDD VSS VSS gf180mcu_fd_sc_mcu7t5v0__fill_2
XFILLER_4_104 VDD VDD VSS VSS gf180mcu_fd_sc_mcu7t5v0__fill_1
XFILLER_4_107 VDD VDD VSS VSS gf180mcu_fd_sc_mcu7t5v0__fillcap_8
XFILLER_4_115 VDD VDD VSS VSS gf180mcu_fd_sc_mcu7t5v0__fill_1
XFILLER_4_2 VDD VDD VSS VSS gf180mcu_fd_sc_mcu7t5v0__fillcap_32
XFILLER_4_34 VDD VDD VSS VSS gf180mcu_fd_sc_mcu7t5v0__fill_1
XFILLER_4_37 VDD VDD VSS VSS gf180mcu_fd_sc_mcu7t5v0__fillcap_16
XFILLER_4_53 VDD VDD VSS VSS gf180mcu_fd_sc_mcu7t5v0__fill_2
XFILLER_4_55 VDD VDD VSS VSS gf180mcu_fd_sc_mcu7t5v0__fill_1
XFILLER_4_90 VDD VDD VSS VSS gf180mcu_fd_sc_mcu7t5v0__fillcap_8
XFILLER_4_98 VDD VDD VSS VSS gf180mcu_fd_sc_mcu7t5v0__fillcap_4
XFILLER_5_130 VDD VDD VSS VSS gf180mcu_fd_sc_mcu7t5v0__fillcap_8
XFILLER_5_138 VDD VDD VSS VSS gf180mcu_fd_sc_mcu7t5v0__fill_2
XFILLER_5_142 VDD VDD VSS VSS gf180mcu_fd_sc_mcu7t5v0__fillcap_8
XFILLER_5_150 VDD VDD VSS VSS gf180mcu_fd_sc_mcu7t5v0__fill_2
XFILLER_5_2 VDD VDD VSS VSS gf180mcu_fd_sc_mcu7t5v0__fillcap_64
XFILLER_5_66 VDD VDD VSS VSS gf180mcu_fd_sc_mcu7t5v0__fillcap_4
XFILLER_5_72 VDD VDD VSS VSS gf180mcu_fd_sc_mcu7t5v0__fill_1
XFILLER_6_107 VDD VDD VSS VSS gf180mcu_fd_sc_mcu7t5v0__fillcap_8
XFILLER_6_115 VDD VDD VSS VSS gf180mcu_fd_sc_mcu7t5v0__fillcap_4
XFILLER_6_119 VDD VDD VSS VSS gf180mcu_fd_sc_mcu7t5v0__fill_1
XFILLER_6_2 VDD VDD VSS VSS gf180mcu_fd_sc_mcu7t5v0__fillcap_32
XFILLER_6_34 VDD VDD VSS VSS gf180mcu_fd_sc_mcu7t5v0__fill_1
XFILLER_6_37 VDD VDD VSS VSS gf180mcu_fd_sc_mcu7t5v0__fillcap_16
XFILLER_6_53 VDD VDD VSS VSS gf180mcu_fd_sc_mcu7t5v0__fill_2
XFILLER_7_139 VDD VDD VSS VSS gf180mcu_fd_sc_mcu7t5v0__fill_1
XFILLER_7_146 VDD VDD VSS VSS gf180mcu_fd_sc_mcu7t5v0__fillcap_4
XFILLER_7_150 VDD VDD VSS VSS gf180mcu_fd_sc_mcu7t5v0__fill_2
XFILLER_7_2 VDD VDD VSS VSS gf180mcu_fd_sc_mcu7t5v0__fillcap_32
XFILLER_7_34 VDD VDD VSS VSS gf180mcu_fd_sc_mcu7t5v0__fillcap_16
XFILLER_7_50 VDD VDD VSS VSS gf180mcu_fd_sc_mcu7t5v0__fillcap_8
XFILLER_7_58 VDD VDD VSS VSS gf180mcu_fd_sc_mcu7t5v0__fillcap_4
XFILLER_7_78 VDD VDD VSS VSS gf180mcu_fd_sc_mcu7t5v0__fillcap_8
XFILLER_7_86 VDD VDD VSS VSS gf180mcu_fd_sc_mcu7t5v0__fill_2
XFILLER_7_88 VDD VDD VSS VSS gf180mcu_fd_sc_mcu7t5v0__fill_1
XFILLER_8_107 VDD VDD VSS VSS gf180mcu_fd_sc_mcu7t5v0__fill_2
XFILLER_8_109 VDD VDD VSS VSS gf180mcu_fd_sc_mcu7t5v0__fill_1
XFILLER_8_2 VDD VDD VSS VSS gf180mcu_fd_sc_mcu7t5v0__fillcap_32
XFILLER_8_34 VDD VDD VSS VSS gf180mcu_fd_sc_mcu7t5v0__fill_1
XFILLER_8_37 VDD VDD VSS VSS gf180mcu_fd_sc_mcu7t5v0__fillcap_16
XFILLER_8_53 VDD VDD VSS VSS gf180mcu_fd_sc_mcu7t5v0__fillcap_8
XFILLER_8_61 VDD VDD VSS VSS gf180mcu_fd_sc_mcu7t5v0__fill_1
XFILLER_8_85 VDD VDD VSS VSS gf180mcu_fd_sc_mcu7t5v0__fillcap_16
XFILLER_9_142 VDD VDD VSS VSS gf180mcu_fd_sc_mcu7t5v0__fillcap_8
XFILLER_9_150 VDD VDD VSS VSS gf180mcu_fd_sc_mcu7t5v0__fill_2
XFILLER_9_2 VDD VDD VSS VSS gf180mcu_fd_sc_mcu7t5v0__fillcap_64
XFILLER_9_66 VDD VDD VSS VSS gf180mcu_fd_sc_mcu7t5v0__fillcap_4
XFILLER_9_80 VDD VDD VSS VSS gf180mcu_fd_sc_mcu7t5v0__fillcap_8
XFILLER_9_88 VDD VDD VSS VSS gf180mcu_fd_sc_mcu7t5v0__fill_2
XPHY_EDGE_ROW_0_Left_17 VDD NC_PHY_EDGE_ROW_0_Left_17_VNW NC_PHY_EDGE_ROW_0_Left_17_VPW VSS
+ gf180mcu_fd_sc_mcu7t5v0__endcap
XPHY_EDGE_ROW_0_Right_0 VDD NC_PHY_EDGE_ROW_0_Right_0_VNW NC_PHY_EDGE_ROW_0_Right_0_VPW VSS
+ gf180mcu_fd_sc_mcu7t5v0__endcap
XPHY_EDGE_ROW_10_Left_27 VDD NC_PHY_EDGE_ROW_10_Left_27_VNW NC_PHY_EDGE_ROW_10_Left_27_VPW VSS
+ gf180mcu_fd_sc_mcu7t5v0__endcap
XPHY_EDGE_ROW_10_Right_10 VDD NC_PHY_EDGE_ROW_10_Right_10_VNW NC_PHY_EDGE_ROW_10_Right_10_VPW VSS
+ gf180mcu_fd_sc_mcu7t5v0__endcap
XPHY_EDGE_ROW_11_Left_28 VDD NC_PHY_EDGE_ROW_11_Left_28_VNW NC_PHY_EDGE_ROW_11_Left_28_VPW VSS
+ gf180mcu_fd_sc_mcu7t5v0__endcap
XPHY_EDGE_ROW_11_Right_11 VDD NC_PHY_EDGE_ROW_11_Right_11_VNW NC_PHY_EDGE_ROW_11_Right_11_VPW VSS
+ gf180mcu_fd_sc_mcu7t5v0__endcap
XPHY_EDGE_ROW_12_Left_29 VDD NC_PHY_EDGE_ROW_12_Left_29_VNW NC_PHY_EDGE_ROW_12_Left_29_VPW VSS
+ gf180mcu_fd_sc_mcu7t5v0__endcap
XPHY_EDGE_ROW_12_Right_12 VDD NC_PHY_EDGE_ROW_12_Right_12_VNW NC_PHY_EDGE_ROW_12_Right_12_VPW VSS
+ gf180mcu_fd_sc_mcu7t5v0__endcap
XPHY_EDGE_ROW_13_Left_30 VDD NC_PHY_EDGE_ROW_13_Left_30_VNW NC_PHY_EDGE_ROW_13_Left_30_VPW VSS
+ gf180mcu_fd_sc_mcu7t5v0__endcap
XPHY_EDGE_ROW_13_Right_13 VDD NC_PHY_EDGE_ROW_13_Right_13_VNW NC_PHY_EDGE_ROW_13_Right_13_VPW VSS
+ gf180mcu_fd_sc_mcu7t5v0__endcap
XPHY_EDGE_ROW_14_Left_31 VDD NC_PHY_EDGE_ROW_14_Left_31_VNW NC_PHY_EDGE_ROW_14_Left_31_VPW VSS
+ gf180mcu_fd_sc_mcu7t5v0__endcap
XPHY_EDGE_ROW_14_Right_14 VDD NC_PHY_EDGE_ROW_14_Right_14_VNW NC_PHY_EDGE_ROW_14_Right_14_VPW VSS
+ gf180mcu_fd_sc_mcu7t5v0__endcap
XPHY_EDGE_ROW_15_Left_32 VDD NC_PHY_EDGE_ROW_15_Left_32_VNW NC_PHY_EDGE_ROW_15_Left_32_VPW VSS
+ gf180mcu_fd_sc_mcu7t5v0__endcap
XPHY_EDGE_ROW_15_Right_15 VDD NC_PHY_EDGE_ROW_15_Right_15_VNW NC_PHY_EDGE_ROW_15_Right_15_VPW VSS
+ gf180mcu_fd_sc_mcu7t5v0__endcap
XPHY_EDGE_ROW_16_Left_33 VDD NC_PHY_EDGE_ROW_16_Left_33_VNW NC_PHY_EDGE_ROW_16_Left_33_VPW VSS
+ gf180mcu_fd_sc_mcu7t5v0__endcap
XPHY_EDGE_ROW_16_Right_16 VDD NC_PHY_EDGE_ROW_16_Right_16_VNW NC_PHY_EDGE_ROW_16_Right_16_VPW VSS
+ gf180mcu_fd_sc_mcu7t5v0__endcap
XPHY_EDGE_ROW_1_Left_18 VDD NC_PHY_EDGE_ROW_1_Left_18_VNW NC_PHY_EDGE_ROW_1_Left_18_VPW VSS
+ gf180mcu_fd_sc_mcu7t5v0__endcap
XPHY_EDGE_ROW_1_Right_1 VDD NC_PHY_EDGE_ROW_1_Right_1_VNW NC_PHY_EDGE_ROW_1_Right_1_VPW VSS
+ gf180mcu_fd_sc_mcu7t5v0__endcap
XPHY_EDGE_ROW_2_Left_19 VDD NC_PHY_EDGE_ROW_2_Left_19_VNW NC_PHY_EDGE_ROW_2_Left_19_VPW VSS
+ gf180mcu_fd_sc_mcu7t5v0__endcap
XPHY_EDGE_ROW_2_Right_2 VDD NC_PHY_EDGE_ROW_2_Right_2_VNW NC_PHY_EDGE_ROW_2_Right_2_VPW VSS
+ gf180mcu_fd_sc_mcu7t5v0__endcap
XPHY_EDGE_ROW_3_Left_20 VDD NC_PHY_EDGE_ROW_3_Left_20_VNW NC_PHY_EDGE_ROW_3_Left_20_VPW VSS
+ gf180mcu_fd_sc_mcu7t5v0__endcap
XPHY_EDGE_ROW_3_Right_3 VDD NC_PHY_EDGE_ROW_3_Right_3_VNW NC_PHY_EDGE_ROW_3_Right_3_VPW VSS
+ gf180mcu_fd_sc_mcu7t5v0__endcap
XPHY_EDGE_ROW_4_Left_21 VDD NC_PHY_EDGE_ROW_4_Left_21_VNW NC_PHY_EDGE_ROW_4_Left_21_VPW VSS
+ gf180mcu_fd_sc_mcu7t5v0__endcap
XPHY_EDGE_ROW_4_Right_4 VDD NC_PHY_EDGE_ROW_4_Right_4_VNW NC_PHY_EDGE_ROW_4_Right_4_VPW VSS
+ gf180mcu_fd_sc_mcu7t5v0__endcap
XPHY_EDGE_ROW_5_Left_22 VDD NC_PHY_EDGE_ROW_5_Left_22_VNW NC_PHY_EDGE_ROW_5_Left_22_VPW VSS
+ gf180mcu_fd_sc_mcu7t5v0__endcap
XPHY_EDGE_ROW_5_Right_5 VDD NC_PHY_EDGE_ROW_5_Right_5_VNW NC_PHY_EDGE_ROW_5_Right_5_VPW VSS
+ gf180mcu_fd_sc_mcu7t5v0__endcap
XPHY_EDGE_ROW_6_Left_23 VDD NC_PHY_EDGE_ROW_6_Left_23_VNW NC_PHY_EDGE_ROW_6_Left_23_VPW VSS
+ gf180mcu_fd_sc_mcu7t5v0__endcap
XPHY_EDGE_ROW_6_Right_6 VDD NC_PHY_EDGE_ROW_6_Right_6_VNW NC_PHY_EDGE_ROW_6_Right_6_VPW VSS
+ gf180mcu_fd_sc_mcu7t5v0__endcap
XPHY_EDGE_ROW_7_Left_24 VDD NC_PHY_EDGE_ROW_7_Left_24_VNW NC_PHY_EDGE_ROW_7_Left_24_VPW VSS
+ gf180mcu_fd_sc_mcu7t5v0__endcap
XPHY_EDGE_ROW_7_Right_7 VDD NC_PHY_EDGE_ROW_7_Right_7_VNW NC_PHY_EDGE_ROW_7_Right_7_VPW VSS
+ gf180mcu_fd_sc_mcu7t5v0__endcap
XPHY_EDGE_ROW_8_Left_25 VDD NC_PHY_EDGE_ROW_8_Left_25_VNW NC_PHY_EDGE_ROW_8_Left_25_VPW VSS
+ gf180mcu_fd_sc_mcu7t5v0__endcap
XPHY_EDGE_ROW_8_Right_8 VDD NC_PHY_EDGE_ROW_8_Right_8_VNW NC_PHY_EDGE_ROW_8_Right_8_VPW VSS
+ gf180mcu_fd_sc_mcu7t5v0__endcap
XPHY_EDGE_ROW_9_Left_26 VDD NC_PHY_EDGE_ROW_9_Left_26_VNW NC_PHY_EDGE_ROW_9_Left_26_VPW VSS
+ gf180mcu_fd_sc_mcu7t5v0__endcap
XPHY_EDGE_ROW_9_Right_9 VDD NC_PHY_EDGE_ROW_9_Right_9_VNW NC_PHY_EDGE_ROW_9_Right_9_VPW VSS
+ gf180mcu_fd_sc_mcu7t5v0__endcap
XTAP_TAPCELL_ROW_0_34 VDD VSS gf180mcu_fd_sc_mcu7t5v0__filltie
XTAP_TAPCELL_ROW_0_35 VDD VSS gf180mcu_fd_sc_mcu7t5v0__filltie
XTAP_TAPCELL_ROW_0_36 VDD VSS gf180mcu_fd_sc_mcu7t5v0__filltie
XTAP_TAPCELL_ROW_0_37 VDD VSS gf180mcu_fd_sc_mcu7t5v0__filltie
XTAP_TAPCELL_ROW_10_56 VDD VSS gf180mcu_fd_sc_mcu7t5v0__filltie
XTAP_TAPCELL_ROW_10_57 VDD VSS gf180mcu_fd_sc_mcu7t5v0__filltie
XTAP_TAPCELL_ROW_11_58 VDD VSS gf180mcu_fd_sc_mcu7t5v0__filltie
XTAP_TAPCELL_ROW_11_59 VDD VSS gf180mcu_fd_sc_mcu7t5v0__filltie
XTAP_TAPCELL_ROW_12_60 VDD VSS gf180mcu_fd_sc_mcu7t5v0__filltie
XTAP_TAPCELL_ROW_12_61 VDD VSS gf180mcu_fd_sc_mcu7t5v0__filltie
XTAP_TAPCELL_ROW_13_62 VDD VSS gf180mcu_fd_sc_mcu7t5v0__filltie
XTAP_TAPCELL_ROW_13_63 VDD VSS gf180mcu_fd_sc_mcu7t5v0__filltie
XTAP_TAPCELL_ROW_14_64 VDD VSS gf180mcu_fd_sc_mcu7t5v0__filltie
XTAP_TAPCELL_ROW_14_65 VDD VSS gf180mcu_fd_sc_mcu7t5v0__filltie
XTAP_TAPCELL_ROW_15_66 VDD VSS gf180mcu_fd_sc_mcu7t5v0__filltie
XTAP_TAPCELL_ROW_15_67 VDD VSS gf180mcu_fd_sc_mcu7t5v0__filltie
XTAP_TAPCELL_ROW_16_68 VDD VSS gf180mcu_fd_sc_mcu7t5v0__filltie
XTAP_TAPCELL_ROW_16_69 VDD VSS gf180mcu_fd_sc_mcu7t5v0__filltie
XTAP_TAPCELL_ROW_16_70 VDD VSS gf180mcu_fd_sc_mcu7t5v0__filltie
XTAP_TAPCELL_ROW_16_71 VDD VSS gf180mcu_fd_sc_mcu7t5v0__filltie
XTAP_TAPCELL_ROW_1_38 VDD VSS gf180mcu_fd_sc_mcu7t5v0__filltie
XTAP_TAPCELL_ROW_1_39 VDD VSS gf180mcu_fd_sc_mcu7t5v0__filltie
XTAP_TAPCELL_ROW_2_40 VDD VSS gf180mcu_fd_sc_mcu7t5v0__filltie
XTAP_TAPCELL_ROW_2_41 VDD VSS gf180mcu_fd_sc_mcu7t5v0__filltie
XTAP_TAPCELL_ROW_3_42 VDD VSS gf180mcu_fd_sc_mcu7t5v0__filltie
XTAP_TAPCELL_ROW_3_43 VDD VSS gf180mcu_fd_sc_mcu7t5v0__filltie
XTAP_TAPCELL_ROW_4_44 VDD VSS gf180mcu_fd_sc_mcu7t5v0__filltie
XTAP_TAPCELL_ROW_4_45 VDD VSS gf180mcu_fd_sc_mcu7t5v0__filltie
XTAP_TAPCELL_ROW_5_46 VDD VSS gf180mcu_fd_sc_mcu7t5v0__filltie
XTAP_TAPCELL_ROW_5_47 VDD VSS gf180mcu_fd_sc_mcu7t5v0__filltie
XTAP_TAPCELL_ROW_6_48 VDD VSS gf180mcu_fd_sc_mcu7t5v0__filltie
XTAP_TAPCELL_ROW_6_49 VDD VSS gf180mcu_fd_sc_mcu7t5v0__filltie
XTAP_TAPCELL_ROW_7_50 VDD VSS gf180mcu_fd_sc_mcu7t5v0__filltie
XTAP_TAPCELL_ROW_7_51 VDD VSS gf180mcu_fd_sc_mcu7t5v0__filltie
XTAP_TAPCELL_ROW_8_52 VDD VSS gf180mcu_fd_sc_mcu7t5v0__filltie
XTAP_TAPCELL_ROW_8_53 VDD VSS gf180mcu_fd_sc_mcu7t5v0__filltie
XTAP_TAPCELL_ROW_9_54 VDD VSS gf180mcu_fd_sc_mcu7t5v0__filltie
XTAP_TAPCELL_ROW_9_55 VDD VSS gf180mcu_fd_sc_mcu7t5v0__filltie
Xn_15 counter_b0 n_06 VDD VDD VSS VSS gf180mcu_fd_sc_mcu7t5v0__clkinv_1
Xn_16 net3 net4 VDD VDD VSS VSS gf180mcu_fd_sc_mcu7t5v0__clkinv_1
Xn_17 net5 n_07 VDD VDD VSS VSS gf180mcu_fd_sc_mcu7t5v0__clkinv_1
Xn_18 counter_b2 counter_b1 n_08 VDD VDD VSS VSS gf180mcu_fd_sc_mcu7t5v0__and2_1
Xn_19 counter_b2 counter_b1 counter_b0 n_00 VDD VDD VSS VSS gf180mcu_fd_sc_mcu7t5v0__aoi21_1
Xn_20 counter_b0 counter_b1 n_09 VDD VDD VSS VSS gf180mcu_fd_sc_mcu7t5v0__and2_1
Xn_21 counter_b0 counter_b1 n_10 VDD VDD VSS VSS gf180mcu_fd_sc_mcu7t5v0__nand2_1
Xn_22 counter_b0 counter_b1 counter_b2 n_11 VDD VDD VSS VSS gf180mcu_fd_sc_mcu7t5v0__aoi21_1
Xn_23 counter_b0 counter_b1 n_12 VDD VDD VSS VSS gf180mcu_fd_sc_mcu7t5v0__nor2_1
Xn_24 counter_b2 n_09 n_12 n_01 VDD VDD VSS VSS gf180mcu_fd_sc_mcu7t5v0__nor3_1
Xn_25 n_09 n_12 counter_b2 n_02 VDD VDD VSS VSS gf180mcu_fd_sc_mcu7t5v0__mux2_2
Xn_26 counter_b2 counter_b1 net2 n_13 VDD VDD VSS VSS gf180mcu_fd_sc_mcu7t5v0__nand3_1
Xn_27 counter_b2 counter_b1 n_13 n_03 VDD VDD VSS VSS gf180mcu_fd_sc_mcu7t5v0__oai21_1
Xn_28 n_06 counter_b2 n_14 VDD VDD VSS VSS gf180mcu_fd_sc_mcu7t5v0__nand2_1
Xn_29 n_10 n_14 net4 n_08 n_04 VDD VDD VSS VSS gf180mcu_fd_sc_mcu7t5v0__aoi22_1
Xn_30 n_07 n_08 n_11 n_05 VDD VDD VSS VSS gf180mcu_fd_sc_mcu7t5v0__aoi21_1
Xn_31 n_03 net1 clknet_1_1__leaf_in_clk net2 VDD VDD VSS VSS gf180mcu_fd_sc_mcu7t5v0__dffsnq_1
Xn_32 n_04 net1 clknet_1_1__leaf_in_clk net3 VDD VDD VSS VSS gf180mcu_fd_sc_mcu7t5v0__dffrnq_1
Xn_33 n_05 net1 clknet_1_1__leaf_in_clk net5 VDD VDD VSS VSS gf180mcu_fd_sc_mcu7t5v0__dffrnq_1
Xn_34 n_00 net1 clknet_1_0__leaf_in_clk counter_b0 VDD VDD VSS VSS gf180mcu_fd_sc_mcu7t5v0__dffrnq_1
Xn_35 n_01 net1 clknet_1_0__leaf_in_clk counter_b1 VDD VDD VSS VSS gf180mcu_fd_sc_mcu7t5v0__dffrnq_1
Xn_36 n_02 net1 clknet_1_0__leaf_in_clk counter_b2 VDD VDD VSS VSS gf180mcu_fd_sc_mcu7t5v0__dffrnq_1
Xclkbuf_0_in_clk in_clk clknet_0_in_clk VDD VDD VSS VSS gf180mcu_fd_sc_mcu7t5v0__clkbuf_16
Xclkbuf_1_0__f_in_clk clknet_0_in_clk clknet_1_0__leaf_in_clk VDD VDD VSS VSS
+ gf180mcu_fd_sc_mcu7t5v0__clkbuf_16
Xclkbuf_1_1__f_in_clk clknet_0_in_clk clknet_1_1__leaf_in_clk VDD VDD VSS VSS
+ gf180mcu_fd_sc_mcu7t5v0__clkbuf_16
Xclkload0 clknet_1_0__leaf_in_clk NC_clkload0_Z VDD VDD VSS VSS gf180mcu_fd_sc_mcu7t5v0__clkbuf_2
Xinput1 rst net1 VDD VDD VSS VSS gf180mcu_fd_sc_mcu7t5v0__dlyb_1
Xoutput2 net2 out_clk1 VDD VDD VSS VSS gf180mcu_fd_sc_mcu7t5v0__dlyb_1
Xoutput3 net3 out_clk2 VDD VDD VSS VSS gf180mcu_fd_sc_mcu7t5v0__dlyb_1
Xoutput4 net4 out_clk2B VDD VDD VSS VSS gf180mcu_fd_sc_mcu7t5v0__dlyb_1
Xoutput5 net5 out_clk_cic VDD VDD VSS VSS gf180mcu_fd_sc_mcu7t5v0__dlyb_1
.ends

* expanding   symbol:  ./cic_filter.sym # of pins=17
** sym_path: cic_filter.sym
** sch_path: cic_filter.sch
.subckt cic_filter clk in_cic rst VDD VSS out_cic_b0 out_cic_b1 out_cic_b2 out_cic_b3 out_cic_b4
+ out_cic_b5 out_cic_b6 out_cic_b7 out_cic_b8 out_cic_b9 out_cic_b10 out_cic_b11
*.PININFO clk:B in_cic:B rst:B VDD:B VSS:B out_cic_b0:B out_cic_b1:B out_cic_b2:B out_cic_b3:B
*+ out_cic_b4:B out_cic_b5:B out_cic_b6:B out_cic_b7:B out_cic_b8:B out_cic_b9:B out_cic_b10:B out_cic_b11:B
XFILLER_0_127 VDD VDD VSS VSS gf180mcu_fd_sc_mcu7t5v0__fill_1
XFILLER_0_138 VDD VDD VSS VSS gf180mcu_fd_sc_mcu7t5v0__fill_2
XFILLER_0_140 VDD VDD VSS VSS gf180mcu_fd_sc_mcu7t5v0__fill_1
XFILLER_0_169 VDD VDD VSS VSS gf180mcu_fd_sc_mcu7t5v0__fill_1
XFILLER_0_18 VDD VDD VSS VSS gf180mcu_fd_sc_mcu7t5v0__fill_2
XFILLER_0_20 VDD VDD VSS VSS gf180mcu_fd_sc_mcu7t5v0__fill_1
XFILLER_0_203 VDD VDD VSS VSS gf180mcu_fd_sc_mcu7t5v0__fill_1
XFILLER_10_102 VDD VDD VSS VSS gf180mcu_fd_sc_mcu7t5v0__fill_2
XFILLER_10_104 VDD VDD VSS VSS gf180mcu_fd_sc_mcu7t5v0__fill_1
XFILLER_10_16 VDD VDD VSS VSS gf180mcu_fd_sc_mcu7t5v0__fill_2
XFILLER_10_18 VDD VDD VSS VSS gf180mcu_fd_sc_mcu7t5v0__fill_1
XFILLER_10_183 VDD VDD VSS VSS gf180mcu_fd_sc_mcu7t5v0__fill_1
XFILLER_10_195 VDD VDD VSS VSS gf180mcu_fd_sc_mcu7t5v0__fill_2
XFILLER_10_197 VDD VDD VSS VSS gf180mcu_fd_sc_mcu7t5v0__fill_1
XFILLER_10_2 VDD VDD VSS VSS gf180mcu_fd_sc_mcu7t5v0__fill_2
XFILLER_10_345 VDD VDD VSS VSS gf180mcu_fd_sc_mcu7t5v0__fill_1
XFILLER_11_142 VDD VDD VSS VSS gf180mcu_fd_sc_mcu7t5v0__fillcap_4
XFILLER_11_197 VDD VDD VSS VSS gf180mcu_fd_sc_mcu7t5v0__fill_2
XFILLER_11_199 VDD VDD VSS VSS gf180mcu_fd_sc_mcu7t5v0__fill_1
XFILLER_11_209 VDD VDD VSS VSS gf180mcu_fd_sc_mcu7t5v0__fill_1
XFILLER_11_221 VDD VDD VSS VSS gf180mcu_fd_sc_mcu7t5v0__fill_2
XFILLER_11_236 VDD VDD VSS VSS gf180mcu_fd_sc_mcu7t5v0__fill_2
XFILLER_11_382 VDD VDD VSS VSS gf180mcu_fd_sc_mcu7t5v0__fill_2
XFILLER_11_45 VDD VDD VSS VSS gf180mcu_fd_sc_mcu7t5v0__fill_1
XFILLER_11_72 VDD VDD VSS VSS gf180mcu_fd_sc_mcu7t5v0__fill_2
XFILLER_12_113 VDD VDD VSS VSS gf180mcu_fd_sc_mcu7t5v0__fill_1
XFILLER_12_211 VDD VDD VSS VSS gf180mcu_fd_sc_mcu7t5v0__fill_1
XFILLER_12_383 VDD VDD VSS VSS gf180mcu_fd_sc_mcu7t5v0__fill_1
XFILLER_12_60 VDD VDD VSS VSS gf180mcu_fd_sc_mcu7t5v0__fill_1
XFILLER_12_95 VDD VDD VSS VSS gf180mcu_fd_sc_mcu7t5v0__fill_2
XFILLER_13_122 VDD VDD VSS VSS gf180mcu_fd_sc_mcu7t5v0__fill_1
XFILLER_13_142 VDD VDD VSS VSS gf180mcu_fd_sc_mcu7t5v0__fill_2
XFILLER_13_155 VDD VDD VSS VSS gf180mcu_fd_sc_mcu7t5v0__fill_1
XFILLER_13_197 VDD VDD VSS VSS gf180mcu_fd_sc_mcu7t5v0__fill_2
XFILLER_13_2 VDD VDD VSS VSS gf180mcu_fd_sc_mcu7t5v0__fill_2
XFILLER_13_216 VDD VDD VSS VSS gf180mcu_fd_sc_mcu7t5v0__fill_1
XFILLER_13_366 VDD VDD VSS VSS gf180mcu_fd_sc_mcu7t5v0__fill_1
XFILLER_13_383 VDD VDD VSS VSS gf180mcu_fd_sc_mcu7t5v0__fill_1
XFILLER_14_102 VDD VDD VSS VSS gf180mcu_fd_sc_mcu7t5v0__fill_2
XFILLER_14_104 VDD VDD VSS VSS gf180mcu_fd_sc_mcu7t5v0__fill_1
XFILLER_14_107 VDD VDD VSS VSS gf180mcu_fd_sc_mcu7t5v0__fillcap_4
XFILLER_14_16 VDD VDD VSS VSS gf180mcu_fd_sc_mcu7t5v0__fill_1
XFILLER_14_173 VDD VDD VSS VSS gf180mcu_fd_sc_mcu7t5v0__fill_2
XFILLER_14_198 VDD VDD VSS VSS gf180mcu_fd_sc_mcu7t5v0__fillcap_4
XFILLER_14_2 VDD VDD VSS VSS gf180mcu_fd_sc_mcu7t5v0__fill_2
XFILLER_14_234 VDD VDD VSS VSS gf180mcu_fd_sc_mcu7t5v0__fill_2
XFILLER_14_240 VDD VDD VSS VSS gf180mcu_fd_sc_mcu7t5v0__fill_1
XFILLER_14_359 VDD VDD VSS VSS gf180mcu_fd_sc_mcu7t5v0__fill_2
XFILLER_14_369 VDD VDD VSS VSS gf180mcu_fd_sc_mcu7t5v0__fill_2
XFILLER_14_371 VDD VDD VSS VSS gf180mcu_fd_sc_mcu7t5v0__fill_1
XFILLER_15_142 VDD VDD VSS VSS gf180mcu_fd_sc_mcu7t5v0__fill_2
XFILLER_15_144 VDD VDD VSS VSS gf180mcu_fd_sc_mcu7t5v0__fill_1
XFILLER_15_154 VDD VDD VSS VSS gf180mcu_fd_sc_mcu7t5v0__fill_2
XFILLER_15_156 VDD VDD VSS VSS gf180mcu_fd_sc_mcu7t5v0__fill_1
XFILLER_15_191 VDD VDD VSS VSS gf180mcu_fd_sc_mcu7t5v0__fill_1
XFILLER_15_202 VDD VDD VSS VSS gf180mcu_fd_sc_mcu7t5v0__fill_2
XFILLER_15_204 VDD VDD VSS VSS gf180mcu_fd_sc_mcu7t5v0__fill_1
XFILLER_15_212 VDD VDD VSS VSS gf180mcu_fd_sc_mcu7t5v0__fill_1
XFILLER_15_255 VDD VDD VSS VSS gf180mcu_fd_sc_mcu7t5v0__fill_1
XFILLER_15_282 VDD VDD VSS VSS gf180mcu_fd_sc_mcu7t5v0__fill_2
XFILLER_15_307 VDD VDD VSS VSS gf180mcu_fd_sc_mcu7t5v0__fill_2
XFILLER_15_348 VDD VDD VSS VSS gf180mcu_fd_sc_mcu7t5v0__fill_2
XFILLER_15_352 VDD VDD VSS VSS gf180mcu_fd_sc_mcu7t5v0__fillcap_4
XFILLER_15_356 VDD VDD VSS VSS gf180mcu_fd_sc_mcu7t5v0__fill_1
XFILLER_15_36 VDD VDD VSS VSS gf180mcu_fd_sc_mcu7t5v0__fill_1
XFILLER_15_68 VDD VDD VSS VSS gf180mcu_fd_sc_mcu7t5v0__fill_2
XFILLER_15_95 VDD VDD VSS VSS gf180mcu_fd_sc_mcu7t5v0__fill_2
XFILLER_15_97 VDD VDD VSS VSS gf180mcu_fd_sc_mcu7t5v0__fill_1
XFILLER_16_107 VDD VDD VSS VSS gf180mcu_fd_sc_mcu7t5v0__fill_1
XFILLER_16_170 VDD VDD VSS VSS gf180mcu_fd_sc_mcu7t5v0__fillcap_4
XFILLER_16_174 VDD VDD VSS VSS gf180mcu_fd_sc_mcu7t5v0__fill_1
XFILLER_16_189 VDD VDD VSS VSS gf180mcu_fd_sc_mcu7t5v0__fill_2
XFILLER_16_191 VDD VDD VSS VSS gf180mcu_fd_sc_mcu7t5v0__fill_1
XFILLER_16_2 VDD VDD VSS VSS gf180mcu_fd_sc_mcu7t5v0__fill_2
XFILLER_16_204 VDD VDD VSS VSS gf180mcu_fd_sc_mcu7t5v0__fillcap_4
XFILLER_16_208 VDD VDD VSS VSS gf180mcu_fd_sc_mcu7t5v0__fill_2
XFILLER_16_210 VDD VDD VSS VSS gf180mcu_fd_sc_mcu7t5v0__fill_1
XFILLER_16_368 VDD VDD VSS VSS gf180mcu_fd_sc_mcu7t5v0__fill_2
XFILLER_16_382 VDD VDD VSS VSS gf180mcu_fd_sc_mcu7t5v0__fill_2
XFILLER_16_4 VDD VDD VSS VSS gf180mcu_fd_sc_mcu7t5v0__fill_1
XFILLER_16_45 VDD VDD VSS VSS gf180mcu_fd_sc_mcu7t5v0__fill_2
XFILLER_17_109 VDD VDD VSS VSS gf180mcu_fd_sc_mcu7t5v0__fillcap_4
XFILLER_17_136 VDD VDD VSS VSS gf180mcu_fd_sc_mcu7t5v0__fillcap_4
XFILLER_17_149 VDD VDD VSS VSS gf180mcu_fd_sc_mcu7t5v0__fill_2
XFILLER_17_2 VDD VDD VSS VSS gf180mcu_fd_sc_mcu7t5v0__fill_2
XFILLER_17_20 VDD VDD VSS VSS gf180mcu_fd_sc_mcu7t5v0__fill_2
XFILLER_17_208 VDD VDD VSS VSS gf180mcu_fd_sc_mcu7t5v0__fill_2
XFILLER_17_217 VDD VDD VSS VSS gf180mcu_fd_sc_mcu7t5v0__fill_2
XFILLER_17_219 VDD VDD VSS VSS gf180mcu_fd_sc_mcu7t5v0__fill_1
XFILLER_17_22 VDD VDD VSS VSS gf180mcu_fd_sc_mcu7t5v0__fill_1
XFILLER_17_279 VDD VDD VSS VSS gf180mcu_fd_sc_mcu7t5v0__fill_1
XFILLER_17_352 VDD VDD VSS VSS gf180mcu_fd_sc_mcu7t5v0__fill_2
XFILLER_17_354 VDD VDD VSS VSS gf180mcu_fd_sc_mcu7t5v0__fill_1
XFILLER_17_69 VDD VDD VSS VSS gf180mcu_fd_sc_mcu7t5v0__fill_1
XFILLER_17_72 VDD VDD VSS VSS gf180mcu_fd_sc_mcu7t5v0__fillcap_4
XFILLER_17_82 VDD VDD VSS VSS gf180mcu_fd_sc_mcu7t5v0__fill_2
XFILLER_18_126 VDD VDD VSS VSS gf180mcu_fd_sc_mcu7t5v0__fill_2
XFILLER_18_128 VDD VDD VSS VSS gf180mcu_fd_sc_mcu7t5v0__fill_1
XFILLER_18_163 VDD VDD VSS VSS gf180mcu_fd_sc_mcu7t5v0__fill_2
XFILLER_18_165 VDD VDD VSS VSS gf180mcu_fd_sc_mcu7t5v0__fill_1
XFILLER_18_177 VDD VDD VSS VSS gf180mcu_fd_sc_mcu7t5v0__fillcap_4
XFILLER_18_181 VDD VDD VSS VSS gf180mcu_fd_sc_mcu7t5v0__fill_2
XFILLER_18_183 VDD VDD VSS VSS gf180mcu_fd_sc_mcu7t5v0__fill_1
XFILLER_18_189 VDD VDD VSS VSS gf180mcu_fd_sc_mcu7t5v0__fillcap_8
XFILLER_18_2 VDD VDD VSS VSS gf180mcu_fd_sc_mcu7t5v0__fill_2
XFILLER_18_212 VDD VDD VSS VSS gf180mcu_fd_sc_mcu7t5v0__fill_2
XFILLER_18_226 VDD VDD VSS VSS gf180mcu_fd_sc_mcu7t5v0__fillcap_8
XFILLER_18_234 VDD VDD VSS VSS gf180mcu_fd_sc_mcu7t5v0__fillcap_4
XFILLER_18_238 VDD VDD VSS VSS gf180mcu_fd_sc_mcu7t5v0__fill_2
XFILLER_18_240 VDD VDD VSS VSS gf180mcu_fd_sc_mcu7t5v0__fill_1
XFILLER_18_317 VDD VDD VSS VSS gf180mcu_fd_sc_mcu7t5v0__fill_2
XFILLER_18_353 VDD VDD VSS VSS gf180mcu_fd_sc_mcu7t5v0__fillcap_8
XFILLER_18_361 VDD VDD VSS VSS gf180mcu_fd_sc_mcu7t5v0__fillcap_4
XFILLER_18_365 VDD VDD VSS VSS gf180mcu_fd_sc_mcu7t5v0__fill_2
XFILLER_18_4 VDD VDD VSS VSS gf180mcu_fd_sc_mcu7t5v0__fill_1
XFILLER_18_47 VDD VDD VSS VSS gf180mcu_fd_sc_mcu7t5v0__fill_2
XFILLER_18_57 VDD VDD VSS VSS gf180mcu_fd_sc_mcu7t5v0__fill_2
XFILLER_19_103 VDD VDD VSS VSS gf180mcu_fd_sc_mcu7t5v0__fillcap_4
XFILLER_19_138 VDD VDD VSS VSS gf180mcu_fd_sc_mcu7t5v0__fill_2
XFILLER_19_176 VDD VDD VSS VSS gf180mcu_fd_sc_mcu7t5v0__fill_1
XFILLER_19_212 VDD VDD VSS VSS gf180mcu_fd_sc_mcu7t5v0__fill_2
XFILLER_19_214 VDD VDD VSS VSS gf180mcu_fd_sc_mcu7t5v0__fill_1
XFILLER_19_223 VDD VDD VSS VSS gf180mcu_fd_sc_mcu7t5v0__fillcap_4
XFILLER_19_227 VDD VDD VSS VSS gf180mcu_fd_sc_mcu7t5v0__fill_2
XFILLER_19_263 VDD VDD VSS VSS gf180mcu_fd_sc_mcu7t5v0__fill_1
XFILLER_19_278 VDD VDD VSS VSS gf180mcu_fd_sc_mcu7t5v0__fill_2
XFILLER_19_344 VDD VDD VSS VSS gf180mcu_fd_sc_mcu7t5v0__fillcap_4
XFILLER_19_348 VDD VDD VSS VSS gf180mcu_fd_sc_mcu7t5v0__fill_2
XFILLER_19_352 VDD VDD VSS VSS gf180mcu_fd_sc_mcu7t5v0__fillcap_4
XFILLER_19_356 VDD VDD VSS VSS gf180mcu_fd_sc_mcu7t5v0__fill_2
XFILLER_19_45 VDD VDD VSS VSS gf180mcu_fd_sc_mcu7t5v0__fill_1
XFILLER_1_348 VDD VDD VSS VSS gf180mcu_fd_sc_mcu7t5v0__fill_2
XFILLER_1_357 VDD VDD VSS VSS gf180mcu_fd_sc_mcu7t5v0__fill_2
XFILLER_1_359 VDD VDD VSS VSS gf180mcu_fd_sc_mcu7t5v0__fill_1
XFILLER_20_104 VDD VDD VSS VSS gf180mcu_fd_sc_mcu7t5v0__fill_1
XFILLER_20_107 VDD VDD VSS VSS gf180mcu_fd_sc_mcu7t5v0__fill_2
XFILLER_20_130 VDD VDD VSS VSS gf180mcu_fd_sc_mcu7t5v0__fill_2
XFILLER_20_132 VDD VDD VSS VSS gf180mcu_fd_sc_mcu7t5v0__fill_1
XFILLER_20_167 VDD VDD VSS VSS gf180mcu_fd_sc_mcu7t5v0__fill_1
XFILLER_20_173 VDD VDD VSS VSS gf180mcu_fd_sc_mcu7t5v0__fill_2
XFILLER_20_200 VDD VDD VSS VSS gf180mcu_fd_sc_mcu7t5v0__fill_1
XFILLER_20_230 VDD VDD VSS VSS gf180mcu_fd_sc_mcu7t5v0__fillcap_8
XFILLER_20_238 VDD VDD VSS VSS gf180mcu_fd_sc_mcu7t5v0__fill_2
XFILLER_20_240 VDD VDD VSS VSS gf180mcu_fd_sc_mcu7t5v0__fill_1
XFILLER_20_247 VDD VDD VSS VSS gf180mcu_fd_sc_mcu7t5v0__fill_2
XFILLER_20_249 VDD VDD VSS VSS gf180mcu_fd_sc_mcu7t5v0__fill_1
XFILLER_20_302 VDD VDD VSS VSS gf180mcu_fd_sc_mcu7t5v0__fill_1
XFILLER_20_351 VDD VDD VSS VSS gf180mcu_fd_sc_mcu7t5v0__fill_2
XFILLER_20_366 VDD VDD VSS VSS gf180mcu_fd_sc_mcu7t5v0__fill_2
XFILLER_20_37 VDD VDD VSS VSS gf180mcu_fd_sc_mcu7t5v0__fill_1
XFILLER_20_54 VDD VDD VSS VSS gf180mcu_fd_sc_mcu7t5v0__fill_2
XFILLER_20_56 VDD VDD VSS VSS gf180mcu_fd_sc_mcu7t5v0__fill_1
XFILLER_21_105 VDD VDD VSS VSS gf180mcu_fd_sc_mcu7t5v0__fill_2
XFILLER_21_139 VDD VDD VSS VSS gf180mcu_fd_sc_mcu7t5v0__fill_1
XFILLER_21_142 VDD VDD VSS VSS gf180mcu_fd_sc_mcu7t5v0__fillcap_8
XFILLER_21_150 VDD VDD VSS VSS gf180mcu_fd_sc_mcu7t5v0__fill_2
XFILLER_21_160 VDD VDD VSS VSS gf180mcu_fd_sc_mcu7t5v0__fill_1
XFILLER_21_171 VDD VDD VSS VSS gf180mcu_fd_sc_mcu7t5v0__fill_2
XFILLER_21_178 VDD VDD VSS VSS gf180mcu_fd_sc_mcu7t5v0__fill_1
XFILLER_21_188 VDD VDD VSS VSS gf180mcu_fd_sc_mcu7t5v0__fillcap_8
XFILLER_21_204 VDD VDD VSS VSS gf180mcu_fd_sc_mcu7t5v0__fillcap_4
XFILLER_21_208 VDD VDD VSS VSS gf180mcu_fd_sc_mcu7t5v0__fill_2
XFILLER_21_220 VDD VDD VSS VSS gf180mcu_fd_sc_mcu7t5v0__fill_2
XFILLER_21_256 VDD VDD VSS VSS gf180mcu_fd_sc_mcu7t5v0__fill_1
XFILLER_21_282 VDD VDD VSS VSS gf180mcu_fd_sc_mcu7t5v0__fill_2
XFILLER_21_284 VDD VDD VSS VSS gf180mcu_fd_sc_mcu7t5v0__fill_1
XFILLER_21_306 VDD VDD VSS VSS gf180mcu_fd_sc_mcu7t5v0__fill_1
XFILLER_21_36 VDD VDD VSS VSS gf180mcu_fd_sc_mcu7t5v0__fill_1
XFILLER_21_382 VDD VDD VSS VSS gf180mcu_fd_sc_mcu7t5v0__fill_2
XFILLER_21_72 VDD VDD VSS VSS gf180mcu_fd_sc_mcu7t5v0__fill_2
XFILLER_21_74 VDD VDD VSS VSS gf180mcu_fd_sc_mcu7t5v0__fill_1
XFILLER_21_96 VDD VDD VSS VSS gf180mcu_fd_sc_mcu7t5v0__fillcap_4
XFILLER_22_115 VDD VDD VSS VSS gf180mcu_fd_sc_mcu7t5v0__fill_2
XFILLER_22_117 VDD VDD VSS VSS gf180mcu_fd_sc_mcu7t5v0__fill_1
XFILLER_22_174 VDD VDD VSS VSS gf180mcu_fd_sc_mcu7t5v0__fill_1
XFILLER_22_188 VDD VDD VSS VSS gf180mcu_fd_sc_mcu7t5v0__fill_2
XFILLER_22_2 VDD VDD VSS VSS gf180mcu_fd_sc_mcu7t5v0__fill_2
XFILLER_22_204 VDD VDD VSS VSS gf180mcu_fd_sc_mcu7t5v0__fillcap_4
XFILLER_22_208 VDD VDD VSS VSS gf180mcu_fd_sc_mcu7t5v0__fill_2
XFILLER_22_21 VDD VDD VSS VSS gf180mcu_fd_sc_mcu7t5v0__fillcap_4
XFILLER_22_226 VDD VDD VSS VSS gf180mcu_fd_sc_mcu7t5v0__fillcap_16
XFILLER_22_242 VDD VDD VSS VSS gf180mcu_fd_sc_mcu7t5v0__fill_2
XFILLER_22_244 VDD VDD VSS VSS gf180mcu_fd_sc_mcu7t5v0__fill_1
XFILLER_22_247 VDD VDD VSS VSS gf180mcu_fd_sc_mcu7t5v0__fillcap_4
XFILLER_22_265 VDD VDD VSS VSS gf180mcu_fd_sc_mcu7t5v0__fill_2
XFILLER_22_267 VDD VDD VSS VSS gf180mcu_fd_sc_mcu7t5v0__fill_1
XFILLER_22_277 VDD VDD VSS VSS gf180mcu_fd_sc_mcu7t5v0__fill_2
XFILLER_22_293 VDD VDD VSS VSS gf180mcu_fd_sc_mcu7t5v0__fill_2
XFILLER_22_329 VDD VDD VSS VSS gf180mcu_fd_sc_mcu7t5v0__fill_1
XFILLER_22_58 VDD VDD VSS VSS gf180mcu_fd_sc_mcu7t5v0__fillcap_8
XFILLER_22_66 VDD VDD VSS VSS gf180mcu_fd_sc_mcu7t5v0__fillcap_4
XFILLER_22_70 VDD VDD VSS VSS gf180mcu_fd_sc_mcu7t5v0__fill_2
XFILLER_22_77 VDD VDD VSS VSS gf180mcu_fd_sc_mcu7t5v0__fillcap_8
XFILLER_22_85 VDD VDD VSS VSS gf180mcu_fd_sc_mcu7t5v0__fill_1
XFILLER_22_91 VDD VDD VSS VSS gf180mcu_fd_sc_mcu7t5v0__fill_1
XFILLER_23_115 VDD VDD VSS VSS gf180mcu_fd_sc_mcu7t5v0__fill_1
XFILLER_23_124 VDD VDD VSS VSS gf180mcu_fd_sc_mcu7t5v0__fill_2
XFILLER_23_136 VDD VDD VSS VSS gf180mcu_fd_sc_mcu7t5v0__fillcap_4
XFILLER_23_147 VDD VDD VSS VSS gf180mcu_fd_sc_mcu7t5v0__fillcap_8
XFILLER_23_189 VDD VDD VSS VSS gf180mcu_fd_sc_mcu7t5v0__fillcap_8
XFILLER_23_197 VDD VDD VSS VSS gf180mcu_fd_sc_mcu7t5v0__fill_2
XFILLER_23_199 VDD VDD VSS VSS gf180mcu_fd_sc_mcu7t5v0__fill_1
XFILLER_23_2 VDD VDD VSS VSS gf180mcu_fd_sc_mcu7t5v0__fill_1
XFILLER_23_209 VDD VDD VSS VSS gf180mcu_fd_sc_mcu7t5v0__fill_1
XFILLER_23_212 VDD VDD VSS VSS gf180mcu_fd_sc_mcu7t5v0__fill_2
XFILLER_23_214 VDD VDD VSS VSS gf180mcu_fd_sc_mcu7t5v0__fill_1
XFILLER_23_223 VDD VDD VSS VSS gf180mcu_fd_sc_mcu7t5v0__fill_1
XFILLER_23_278 VDD VDD VSS VSS gf180mcu_fd_sc_mcu7t5v0__fill_2
XFILLER_23_282 VDD VDD VSS VSS gf180mcu_fd_sc_mcu7t5v0__fillcap_4
XFILLER_23_302 VDD VDD VSS VSS gf180mcu_fd_sc_mcu7t5v0__fill_2
XFILLER_23_312 VDD VDD VSS VSS gf180mcu_fd_sc_mcu7t5v0__fillcap_4
XFILLER_23_352 VDD VDD VSS VSS gf180mcu_fd_sc_mcu7t5v0__fill_2
XFILLER_23_364 VDD VDD VSS VSS gf180mcu_fd_sc_mcu7t5v0__fill_1
XFILLER_23_382 VDD VDD VSS VSS gf180mcu_fd_sc_mcu7t5v0__fill_2
XFILLER_23_43 VDD VDD VSS VSS gf180mcu_fd_sc_mcu7t5v0__fill_1
XFILLER_23_55 VDD VDD VSS VSS gf180mcu_fd_sc_mcu7t5v0__fill_1
XFILLER_23_61 VDD VDD VSS VSS gf180mcu_fd_sc_mcu7t5v0__fillcap_8
XFILLER_23_69 VDD VDD VSS VSS gf180mcu_fd_sc_mcu7t5v0__fill_1
XFILLER_24_116 VDD VDD VSS VSS gf180mcu_fd_sc_mcu7t5v0__fill_2
XFILLER_24_177 VDD VDD VSS VSS gf180mcu_fd_sc_mcu7t5v0__fillcap_8
XFILLER_24_2 VDD VDD VSS VSS gf180mcu_fd_sc_mcu7t5v0__fill_1
XFILLER_24_203 VDD VDD VSS VSS gf180mcu_fd_sc_mcu7t5v0__fillcap_4
XFILLER_24_207 VDD VDD VSS VSS gf180mcu_fd_sc_mcu7t5v0__fill_2
XFILLER_24_232 VDD VDD VSS VSS gf180mcu_fd_sc_mcu7t5v0__fillcap_8
XFILLER_24_240 VDD VDD VSS VSS gf180mcu_fd_sc_mcu7t5v0__fillcap_4
XFILLER_24_244 VDD VDD VSS VSS gf180mcu_fd_sc_mcu7t5v0__fill_1
XFILLER_24_28 VDD VDD VSS VSS gf180mcu_fd_sc_mcu7t5v0__fillcap_4
XFILLER_24_281 VDD VDD VSS VSS gf180mcu_fd_sc_mcu7t5v0__fill_1
XFILLER_24_293 VDD VDD VSS VSS gf180mcu_fd_sc_mcu7t5v0__fill_2
XFILLER_24_317 VDD VDD VSS VSS gf180mcu_fd_sc_mcu7t5v0__fill_1
XFILLER_24_32 VDD VDD VSS VSS gf180mcu_fd_sc_mcu7t5v0__fill_2
XFILLER_24_34 VDD VDD VSS VSS gf180mcu_fd_sc_mcu7t5v0__fill_1
XFILLER_24_360 VDD VDD VSS VSS gf180mcu_fd_sc_mcu7t5v0__fill_2
XFILLER_24_362 VDD VDD VSS VSS gf180mcu_fd_sc_mcu7t5v0__fill_1
XFILLER_24_37 VDD VDD VSS VSS gf180mcu_fd_sc_mcu7t5v0__fillcap_4
XFILLER_24_51 VDD VDD VSS VSS gf180mcu_fd_sc_mcu7t5v0__fill_2
XFILLER_24_74 VDD VDD VSS VSS gf180mcu_fd_sc_mcu7t5v0__fillcap_4
XFILLER_24_86 VDD VDD VSS VSS gf180mcu_fd_sc_mcu7t5v0__fill_2
XFILLER_24_88 VDD VDD VSS VSS gf180mcu_fd_sc_mcu7t5v0__fill_1
XFILLER_25_139 VDD VDD VSS VSS gf180mcu_fd_sc_mcu7t5v0__fill_1
XFILLER_25_194 VDD VDD VSS VSS gf180mcu_fd_sc_mcu7t5v0__fill_2
XFILLER_25_2 VDD VDD VSS VSS gf180mcu_fd_sc_mcu7t5v0__fillcap_4
XFILLER_25_208 VDD VDD VSS VSS gf180mcu_fd_sc_mcu7t5v0__fill_2
XFILLER_25_212 VDD VDD VSS VSS gf180mcu_fd_sc_mcu7t5v0__fill_2
XFILLER_25_222 VDD VDD VSS VSS gf180mcu_fd_sc_mcu7t5v0__fillcap_4
XFILLER_25_260 VDD VDD VSS VSS gf180mcu_fd_sc_mcu7t5v0__fill_1
XFILLER_25_279 VDD VDD VSS VSS gf180mcu_fd_sc_mcu7t5v0__fill_1
XFILLER_25_282 VDD VDD VSS VSS gf180mcu_fd_sc_mcu7t5v0__fill_2
XFILLER_25_284 VDD VDD VSS VSS gf180mcu_fd_sc_mcu7t5v0__fill_1
XFILLER_25_294 VDD VDD VSS VSS gf180mcu_fd_sc_mcu7t5v0__fillcap_4
XFILLER_25_298 VDD VDD VSS VSS gf180mcu_fd_sc_mcu7t5v0__fill_2
XFILLER_25_352 VDD VDD VSS VSS gf180mcu_fd_sc_mcu7t5v0__fill_1
XFILLER_25_382 VDD VDD VSS VSS gf180mcu_fd_sc_mcu7t5v0__fill_2
XFILLER_25_59 VDD VDD VSS VSS gf180mcu_fd_sc_mcu7t5v0__fillcap_4
XFILLER_25_63 VDD VDD VSS VSS gf180mcu_fd_sc_mcu7t5v0__fill_2
XFILLER_26_138 VDD VDD VSS VSS gf180mcu_fd_sc_mcu7t5v0__fill_2
XFILLER_26_140 VDD VDD VSS VSS gf180mcu_fd_sc_mcu7t5v0__fill_1
XFILLER_26_2 VDD VDD VSS VSS gf180mcu_fd_sc_mcu7t5v0__fill_2
XFILLER_26_204 VDD VDD VSS VSS gf180mcu_fd_sc_mcu7t5v0__fillcap_8
XFILLER_26_212 VDD VDD VSS VSS gf180mcu_fd_sc_mcu7t5v0__fillcap_4
XFILLER_26_216 VDD VDD VSS VSS gf180mcu_fd_sc_mcu7t5v0__fill_1
XFILLER_26_233 VDD VDD VSS VSS gf180mcu_fd_sc_mcu7t5v0__fillcap_8
XFILLER_26_305 VDD VDD VSS VSS gf180mcu_fd_sc_mcu7t5v0__fill_2
XFILLER_26_317 VDD VDD VSS VSS gf180mcu_fd_sc_mcu7t5v0__fillcap_8
XFILLER_26_32 VDD VDD VSS VSS gf180mcu_fd_sc_mcu7t5v0__fill_2
XFILLER_26_325 VDD VDD VSS VSS gf180mcu_fd_sc_mcu7t5v0__fillcap_4
XFILLER_26_329 VDD VDD VSS VSS gf180mcu_fd_sc_mcu7t5v0__fill_2
XFILLER_26_34 VDD VDD VSS VSS gf180mcu_fd_sc_mcu7t5v0__fill_1
XFILLER_26_365 VDD VDD VSS VSS gf180mcu_fd_sc_mcu7t5v0__fill_2
XFILLER_26_37 VDD VDD VSS VSS gf180mcu_fd_sc_mcu7t5v0__fillcap_8
XFILLER_26_4 VDD VDD VSS VSS gf180mcu_fd_sc_mcu7t5v0__fill_1
XFILLER_26_45 VDD VDD VSS VSS gf180mcu_fd_sc_mcu7t5v0__fill_2
XFILLER_26_60 VDD VDD VSS VSS gf180mcu_fd_sc_mcu7t5v0__fillcap_4
XFILLER_26_93 VDD VDD VSS VSS gf180mcu_fd_sc_mcu7t5v0__fillcap_4
XFILLER_27_114 VDD VDD VSS VSS gf180mcu_fd_sc_mcu7t5v0__fillcap_4
XFILLER_27_139 VDD VDD VSS VSS gf180mcu_fd_sc_mcu7t5v0__fill_1
XFILLER_27_142 VDD VDD VSS VSS gf180mcu_fd_sc_mcu7t5v0__fillcap_4
XFILLER_27_146 VDD VDD VSS VSS gf180mcu_fd_sc_mcu7t5v0__fill_2
XFILLER_27_182 VDD VDD VSS VSS gf180mcu_fd_sc_mcu7t5v0__fill_1
XFILLER_27_188 VDD VDD VSS VSS gf180mcu_fd_sc_mcu7t5v0__fillcap_4
XFILLER_27_192 VDD VDD VSS VSS gf180mcu_fd_sc_mcu7t5v0__fill_2
XFILLER_27_194 VDD VDD VSS VSS gf180mcu_fd_sc_mcu7t5v0__fill_1
XFILLER_27_2 VDD VDD VSS VSS gf180mcu_fd_sc_mcu7t5v0__fill_1
XFILLER_27_206 VDD VDD VSS VSS gf180mcu_fd_sc_mcu7t5v0__fillcap_4
XFILLER_27_212 VDD VDD VSS VSS gf180mcu_fd_sc_mcu7t5v0__fill_1
XFILLER_27_232 VDD VDD VSS VSS gf180mcu_fd_sc_mcu7t5v0__fillcap_4
XFILLER_27_236 VDD VDD VSS VSS gf180mcu_fd_sc_mcu7t5v0__fill_1
XFILLER_27_276 VDD VDD VSS VSS gf180mcu_fd_sc_mcu7t5v0__fillcap_4
XFILLER_27_291 VDD VDD VSS VSS gf180mcu_fd_sc_mcu7t5v0__fill_2
XFILLER_27_37 VDD VDD VSS VSS gf180mcu_fd_sc_mcu7t5v0__fillcap_4
XFILLER_27_46 VDD VDD VSS VSS gf180mcu_fd_sc_mcu7t5v0__fillcap_4
XFILLER_28_115 VDD VDD VSS VSS gf180mcu_fd_sc_mcu7t5v0__fill_1
XFILLER_28_126 VDD VDD VSS VSS gf180mcu_fd_sc_mcu7t5v0__fill_1
XFILLER_28_135 VDD VDD VSS VSS gf180mcu_fd_sc_mcu7t5v0__fillcap_4
XFILLER_28_166 VDD VDD VSS VSS gf180mcu_fd_sc_mcu7t5v0__fillcap_8
XFILLER_28_174 VDD VDD VSS VSS gf180mcu_fd_sc_mcu7t5v0__fill_1
XFILLER_28_186 VDD VDD VSS VSS gf180mcu_fd_sc_mcu7t5v0__fill_2
XFILLER_28_2 VDD VDD VSS VSS gf180mcu_fd_sc_mcu7t5v0__fill_1
XFILLER_28_221 VDD VDD VSS VSS gf180mcu_fd_sc_mcu7t5v0__fillcap_8
XFILLER_28_229 VDD VDD VSS VSS gf180mcu_fd_sc_mcu7t5v0__fillcap_4
XFILLER_28_23 VDD VDD VSS VSS gf180mcu_fd_sc_mcu7t5v0__fillcap_8
XFILLER_28_247 VDD VDD VSS VSS gf180mcu_fd_sc_mcu7t5v0__fillcap_4
XFILLER_28_302 VDD VDD VSS VSS gf180mcu_fd_sc_mcu7t5v0__fill_2
XFILLER_28_304 VDD VDD VSS VSS gf180mcu_fd_sc_mcu7t5v0__fill_1
XFILLER_28_31 VDD VDD VSS VSS gf180mcu_fd_sc_mcu7t5v0__fillcap_4
XFILLER_28_37 VDD VDD VSS VSS gf180mcu_fd_sc_mcu7t5v0__fill_2
XFILLER_28_383 VDD VDD VSS VSS gf180mcu_fd_sc_mcu7t5v0__fill_1
XFILLER_28_56 VDD VDD VSS VSS gf180mcu_fd_sc_mcu7t5v0__fillcap_8
XFILLER_28_98 VDD VDD VSS VSS gf180mcu_fd_sc_mcu7t5v0__fill_1
XFILLER_29_105 VDD VDD VSS VSS gf180mcu_fd_sc_mcu7t5v0__fill_2
XFILLER_29_125 VDD VDD VSS VSS gf180mcu_fd_sc_mcu7t5v0__fill_2
XFILLER_29_127 VDD VDD VSS VSS gf180mcu_fd_sc_mcu7t5v0__fill_1
XFILLER_29_136 VDD VDD VSS VSS gf180mcu_fd_sc_mcu7t5v0__fillcap_4
XFILLER_29_150 VDD VDD VSS VSS gf180mcu_fd_sc_mcu7t5v0__fill_1
XFILLER_29_185 VDD VDD VSS VSS gf180mcu_fd_sc_mcu7t5v0__fill_2
XFILLER_29_207 VDD VDD VSS VSS gf180mcu_fd_sc_mcu7t5v0__fill_2
XFILLER_29_209 VDD VDD VSS VSS gf180mcu_fd_sc_mcu7t5v0__fill_1
XFILLER_29_212 VDD VDD VSS VSS gf180mcu_fd_sc_mcu7t5v0__fill_2
XFILLER_29_231 VDD VDD VSS VSS gf180mcu_fd_sc_mcu7t5v0__fillcap_4
XFILLER_29_235 VDD VDD VSS VSS gf180mcu_fd_sc_mcu7t5v0__fill_1
XFILLER_29_270 VDD VDD VSS VSS gf180mcu_fd_sc_mcu7t5v0__fillcap_4
XFILLER_29_274 VDD VDD VSS VSS gf180mcu_fd_sc_mcu7t5v0__fill_2
XFILLER_29_282 VDD VDD VSS VSS gf180mcu_fd_sc_mcu7t5v0__fill_2
XFILLER_29_299 VDD VDD VSS VSS gf180mcu_fd_sc_mcu7t5v0__fill_1
XFILLER_29_352 VDD VDD VSS VSS gf180mcu_fd_sc_mcu7t5v0__fill_2
XFILLER_29_354 VDD VDD VSS VSS gf180mcu_fd_sc_mcu7t5v0__fill_1
XFILLER_29_54 VDD VDD VSS VSS gf180mcu_fd_sc_mcu7t5v0__fill_2
XFILLER_29_61 VDD VDD VSS VSS gf180mcu_fd_sc_mcu7t5v0__fillcap_4
XFILLER_29_85 VDD VDD VSS VSS gf180mcu_fd_sc_mcu7t5v0__fill_2
XFILLER_2_149 VDD VDD VSS VSS gf180mcu_fd_sc_mcu7t5v0__fill_2
XFILLER_2_151 VDD VDD VSS VSS gf180mcu_fd_sc_mcu7t5v0__fill_1
XFILLER_2_185 VDD VDD VSS VSS gf180mcu_fd_sc_mcu7t5v0__fill_2
XFILLER_2_187 VDD VDD VSS VSS gf180mcu_fd_sc_mcu7t5v0__fill_1
XFILLER_2_20 VDD VDD VSS VSS gf180mcu_fd_sc_mcu7t5v0__fill_2
XFILLER_2_200 VDD VDD VSS VSS gf180mcu_fd_sc_mcu7t5v0__fill_2
XFILLER_2_202 VDD VDD VSS VSS gf180mcu_fd_sc_mcu7t5v0__fill_1
XFILLER_2_242 VDD VDD VSS VSS gf180mcu_fd_sc_mcu7t5v0__fill_2
XFILLER_2_244 VDD VDD VSS VSS gf180mcu_fd_sc_mcu7t5v0__fill_1
XFILLER_30_102 VDD VDD VSS VSS gf180mcu_fd_sc_mcu7t5v0__fill_2
XFILLER_30_104 VDD VDD VSS VSS gf180mcu_fd_sc_mcu7t5v0__fill_1
XFILLER_30_127 VDD VDD VSS VSS gf180mcu_fd_sc_mcu7t5v0__fill_1
XFILLER_30_191 VDD VDD VSS VSS gf180mcu_fd_sc_mcu7t5v0__fillcap_4
XFILLER_30_195 VDD VDD VSS VSS gf180mcu_fd_sc_mcu7t5v0__fill_1
XFILLER_30_2 VDD VDD VSS VSS gf180mcu_fd_sc_mcu7t5v0__fill_1
XFILLER_30_205 VDD VDD VSS VSS gf180mcu_fd_sc_mcu7t5v0__fill_2
XFILLER_30_207 VDD VDD VSS VSS gf180mcu_fd_sc_mcu7t5v0__fill_1
XFILLER_30_213 VDD VDD VSS VSS gf180mcu_fd_sc_mcu7t5v0__fillcap_8
XFILLER_30_221 VDD VDD VSS VSS gf180mcu_fd_sc_mcu7t5v0__fill_2
XFILLER_30_23 VDD VDD VSS VSS gf180mcu_fd_sc_mcu7t5v0__fillcap_4
XFILLER_30_244 VDD VDD VSS VSS gf180mcu_fd_sc_mcu7t5v0__fill_1
XFILLER_30_247 VDD VDD VSS VSS gf180mcu_fd_sc_mcu7t5v0__fill_2
XFILLER_30_249 VDD VDD VSS VSS gf180mcu_fd_sc_mcu7t5v0__fill_1
XFILLER_30_27 VDD VDD VSS VSS gf180mcu_fd_sc_mcu7t5v0__fill_2
XFILLER_30_29 VDD VDD VSS VSS gf180mcu_fd_sc_mcu7t5v0__fill_1
XFILLER_30_298 VDD VDD VSS VSS gf180mcu_fd_sc_mcu7t5v0__fill_1
XFILLER_30_313 VDD VDD VSS VSS gf180mcu_fd_sc_mcu7t5v0__fill_2
XFILLER_30_322 VDD VDD VSS VSS gf180mcu_fd_sc_mcu7t5v0__fillcap_16
XFILLER_30_338 VDD VDD VSS VSS gf180mcu_fd_sc_mcu7t5v0__fillcap_4
XFILLER_30_342 VDD VDD VSS VSS gf180mcu_fd_sc_mcu7t5v0__fill_2
XFILLER_30_344 VDD VDD VSS VSS gf180mcu_fd_sc_mcu7t5v0__fill_1
XFILLER_30_37 VDD VDD VSS VSS gf180mcu_fd_sc_mcu7t5v0__fill_1
XFILLER_30_67 VDD VDD VSS VSS gf180mcu_fd_sc_mcu7t5v0__fill_1
XFILLER_31_106 VDD VDD VSS VSS gf180mcu_fd_sc_mcu7t5v0__fill_2
XFILLER_31_108 VDD VDD VSS VSS gf180mcu_fd_sc_mcu7t5v0__fill_1
XFILLER_31_136 VDD VDD VSS VSS gf180mcu_fd_sc_mcu7t5v0__fillcap_4
XFILLER_31_142 VDD VDD VSS VSS gf180mcu_fd_sc_mcu7t5v0__fill_1
XFILLER_31_155 VDD VDD VSS VSS gf180mcu_fd_sc_mcu7t5v0__fill_2
XFILLER_31_196 VDD VDD VSS VSS gf180mcu_fd_sc_mcu7t5v0__fill_2
XFILLER_31_208 VDD VDD VSS VSS gf180mcu_fd_sc_mcu7t5v0__fill_2
XFILLER_31_212 VDD VDD VSS VSS gf180mcu_fd_sc_mcu7t5v0__fill_2
XFILLER_31_214 VDD VDD VSS VSS gf180mcu_fd_sc_mcu7t5v0__fill_1
XFILLER_31_223 VDD VDD VSS VSS gf180mcu_fd_sc_mcu7t5v0__fill_2
XFILLER_31_225 VDD VDD VSS VSS gf180mcu_fd_sc_mcu7t5v0__fill_1
XFILLER_31_234 VDD VDD VSS VSS gf180mcu_fd_sc_mcu7t5v0__fill_2
XFILLER_31_270 VDD VDD VSS VSS gf180mcu_fd_sc_mcu7t5v0__fillcap_4
XFILLER_31_274 VDD VDD VSS VSS gf180mcu_fd_sc_mcu7t5v0__fill_2
XFILLER_31_292 VDD VDD VSS VSS gf180mcu_fd_sc_mcu7t5v0__fillcap_4
XFILLER_31_296 VDD VDD VSS VSS gf180mcu_fd_sc_mcu7t5v0__fill_2
XFILLER_31_36 VDD VDD VSS VSS gf180mcu_fd_sc_mcu7t5v0__fill_2
XFILLER_31_38 VDD VDD VSS VSS gf180mcu_fd_sc_mcu7t5v0__fill_1
XFILLER_31_67 VDD VDD VSS VSS gf180mcu_fd_sc_mcu7t5v0__fill_2
XFILLER_31_69 VDD VDD VSS VSS gf180mcu_fd_sc_mcu7t5v0__fill_1
XFILLER_32_107 VDD VDD VSS VSS gf180mcu_fd_sc_mcu7t5v0__fill_2
XFILLER_32_159 VDD VDD VSS VSS gf180mcu_fd_sc_mcu7t5v0__fillcap_16
XFILLER_32_177 VDD VDD VSS VSS gf180mcu_fd_sc_mcu7t5v0__fillcap_4
XFILLER_32_181 VDD VDD VSS VSS gf180mcu_fd_sc_mcu7t5v0__fill_2
XFILLER_32_196 VDD VDD VSS VSS gf180mcu_fd_sc_mcu7t5v0__fill_2
XFILLER_32_198 VDD VDD VSS VSS gf180mcu_fd_sc_mcu7t5v0__fill_1
XFILLER_32_2 VDD VDD VSS VSS gf180mcu_fd_sc_mcu7t5v0__fill_1
XFILLER_32_207 VDD VDD VSS VSS gf180mcu_fd_sc_mcu7t5v0__fillcap_4
XFILLER_32_211 VDD VDD VSS VSS gf180mcu_fd_sc_mcu7t5v0__fill_1
XFILLER_32_217 VDD VDD VSS VSS gf180mcu_fd_sc_mcu7t5v0__fillcap_8
XFILLER_32_225 VDD VDD VSS VSS gf180mcu_fd_sc_mcu7t5v0__fill_2
XFILLER_32_232 VDD VDD VSS VSS gf180mcu_fd_sc_mcu7t5v0__fillcap_8
XFILLER_32_240 VDD VDD VSS VSS gf180mcu_fd_sc_mcu7t5v0__fillcap_4
XFILLER_32_244 VDD VDD VSS VSS gf180mcu_fd_sc_mcu7t5v0__fill_1
XFILLER_32_247 VDD VDD VSS VSS gf180mcu_fd_sc_mcu7t5v0__fillcap_16
XFILLER_32_273 VDD VDD VSS VSS gf180mcu_fd_sc_mcu7t5v0__fillcap_4
XFILLER_32_277 VDD VDD VSS VSS gf180mcu_fd_sc_mcu7t5v0__fill_1
XFILLER_32_306 VDD VDD VSS VSS gf180mcu_fd_sc_mcu7t5v0__fillcap_8
XFILLER_32_314 VDD VDD VSS VSS gf180mcu_fd_sc_mcu7t5v0__fill_1
XFILLER_32_317 VDD VDD VSS VSS gf180mcu_fd_sc_mcu7t5v0__fillcap_8
XFILLER_32_325 VDD VDD VSS VSS gf180mcu_fd_sc_mcu7t5v0__fill_2
XFILLER_32_37 VDD VDD VSS VSS gf180mcu_fd_sc_mcu7t5v0__fill_2
XFILLER_32_39 VDD VDD VSS VSS gf180mcu_fd_sc_mcu7t5v0__fill_1
XFILLER_32_90 VDD VDD VSS VSS gf180mcu_fd_sc_mcu7t5v0__fill_1
XFILLER_33_106 VDD VDD VSS VSS gf180mcu_fd_sc_mcu7t5v0__fill_2
XFILLER_33_137 VDD VDD VSS VSS gf180mcu_fd_sc_mcu7t5v0__fill_2
XFILLER_33_139 VDD VDD VSS VSS gf180mcu_fd_sc_mcu7t5v0__fill_1
XFILLER_33_147 VDD VDD VSS VSS gf180mcu_fd_sc_mcu7t5v0__fill_2
XFILLER_33_149 VDD VDD VSS VSS gf180mcu_fd_sc_mcu7t5v0__fill_1
XFILLER_33_189 VDD VDD VSS VSS gf180mcu_fd_sc_mcu7t5v0__fill_2
XFILLER_33_204 VDD VDD VSS VSS gf180mcu_fd_sc_mcu7t5v0__fillcap_4
XFILLER_33_208 VDD VDD VSS VSS gf180mcu_fd_sc_mcu7t5v0__fill_2
XFILLER_33_246 VDD VDD VSS VSS gf180mcu_fd_sc_mcu7t5v0__fillcap_8
XFILLER_33_254 VDD VDD VSS VSS gf180mcu_fd_sc_mcu7t5v0__fill_2
XFILLER_33_256 VDD VDD VSS VSS gf180mcu_fd_sc_mcu7t5v0__fill_1
XFILLER_33_278 VDD VDD VSS VSS gf180mcu_fd_sc_mcu7t5v0__fill_2
XFILLER_33_282 VDD VDD VSS VSS gf180mcu_fd_sc_mcu7t5v0__fill_2
XFILLER_33_290 VDD VDD VSS VSS gf180mcu_fd_sc_mcu7t5v0__fill_2
XFILLER_33_304 VDD VDD VSS VSS gf180mcu_fd_sc_mcu7t5v0__fillcap_4
XFILLER_33_359 VDD VDD VSS VSS gf180mcu_fd_sc_mcu7t5v0__fill_1
XFILLER_33_36 VDD VDD VSS VSS gf180mcu_fd_sc_mcu7t5v0__fillcap_4
XFILLER_33_55 VDD VDD VSS VSS gf180mcu_fd_sc_mcu7t5v0__fill_2
XFILLER_34_123 VDD VDD VSS VSS gf180mcu_fd_sc_mcu7t5v0__fillcap_4
XFILLER_34_166 VDD VDD VSS VSS gf180mcu_fd_sc_mcu7t5v0__fill_2
XFILLER_34_168 VDD VDD VSS VSS gf180mcu_fd_sc_mcu7t5v0__fill_1
XFILLER_34_17 VDD VDD VSS VSS gf180mcu_fd_sc_mcu7t5v0__fill_1
XFILLER_34_181 VDD VDD VSS VSS gf180mcu_fd_sc_mcu7t5v0__fillcap_4
XFILLER_34_185 VDD VDD VSS VSS gf180mcu_fd_sc_mcu7t5v0__fill_1
XFILLER_34_2 VDD VDD VSS VSS gf180mcu_fd_sc_mcu7t5v0__fillcap_4
XFILLER_34_210 VDD VDD VSS VSS gf180mcu_fd_sc_mcu7t5v0__fill_1
XFILLER_34_247 VDD VDD VSS VSS gf180mcu_fd_sc_mcu7t5v0__fillcap_8
XFILLER_34_255 VDD VDD VSS VSS gf180mcu_fd_sc_mcu7t5v0__fill_2
XFILLER_34_257 VDD VDD VSS VSS gf180mcu_fd_sc_mcu7t5v0__fill_1
XFILLER_34_274 VDD VDD VSS VSS gf180mcu_fd_sc_mcu7t5v0__fill_2
XFILLER_34_276 VDD VDD VSS VSS gf180mcu_fd_sc_mcu7t5v0__fill_1
XFILLER_34_287 VDD VDD VSS VSS gf180mcu_fd_sc_mcu7t5v0__fill_1
XFILLER_34_306 VDD VDD VSS VSS gf180mcu_fd_sc_mcu7t5v0__fillcap_8
XFILLER_34_314 VDD VDD VSS VSS gf180mcu_fd_sc_mcu7t5v0__fill_1
XFILLER_34_366 VDD VDD VSS VSS gf180mcu_fd_sc_mcu7t5v0__fill_2
XFILLER_34_57 VDD VDD VSS VSS gf180mcu_fd_sc_mcu7t5v0__fill_1
XFILLER_34_92 VDD VDD VSS VSS gf180mcu_fd_sc_mcu7t5v0__fill_1
XFILLER_35_112 VDD VDD VSS VSS gf180mcu_fd_sc_mcu7t5v0__fill_2
XFILLER_35_114 VDD VDD VSS VSS gf180mcu_fd_sc_mcu7t5v0__fill_1
XFILLER_35_188 VDD VDD VSS VSS gf180mcu_fd_sc_mcu7t5v0__fillcap_4
XFILLER_35_192 VDD VDD VSS VSS gf180mcu_fd_sc_mcu7t5v0__fill_2
XFILLER_35_204 VDD VDD VSS VSS gf180mcu_fd_sc_mcu7t5v0__fillcap_4
XFILLER_35_208 VDD VDD VSS VSS gf180mcu_fd_sc_mcu7t5v0__fill_2
XFILLER_35_282 VDD VDD VSS VSS gf180mcu_fd_sc_mcu7t5v0__fill_2
XFILLER_35_330 VDD VDD VSS VSS gf180mcu_fd_sc_mcu7t5v0__fill_1
XFILLER_35_349 VDD VDD VSS VSS gf180mcu_fd_sc_mcu7t5v0__fill_1
XFILLER_35_383 VDD VDD VSS VSS gf180mcu_fd_sc_mcu7t5v0__fill_1
XFILLER_35_67 VDD VDD VSS VSS gf180mcu_fd_sc_mcu7t5v0__fill_2
XFILLER_35_69 VDD VDD VSS VSS gf180mcu_fd_sc_mcu7t5v0__fill_1
XFILLER_35_84 VDD VDD VSS VSS gf180mcu_fd_sc_mcu7t5v0__fill_2
XFILLER_35_86 VDD VDD VSS VSS gf180mcu_fd_sc_mcu7t5v0__fill_1
XFILLER_36_107 VDD VDD VSS VSS gf180mcu_fd_sc_mcu7t5v0__fill_2
XFILLER_36_165 VDD VDD VSS VSS gf180mcu_fd_sc_mcu7t5v0__fill_1
XFILLER_36_197 VDD VDD VSS VSS gf180mcu_fd_sc_mcu7t5v0__fillcap_4
XFILLER_36_2 VDD VDD VSS VSS gf180mcu_fd_sc_mcu7t5v0__fillcap_4
XFILLER_36_201 VDD VDD VSS VSS gf180mcu_fd_sc_mcu7t5v0__fill_2
XFILLER_36_247 VDD VDD VSS VSS gf180mcu_fd_sc_mcu7t5v0__fill_2
XFILLER_36_249 VDD VDD VSS VSS gf180mcu_fd_sc_mcu7t5v0__fill_1
XFILLER_36_37 VDD VDD VSS VSS gf180mcu_fd_sc_mcu7t5v0__fill_2
XFILLER_36_381 VDD VDD VSS VSS gf180mcu_fd_sc_mcu7t5v0__fill_2
XFILLER_36_383 VDD VDD VSS VSS gf180mcu_fd_sc_mcu7t5v0__fill_1
XFILLER_36_39 VDD VDD VSS VSS gf180mcu_fd_sc_mcu7t5v0__fill_1
XFILLER_36_57 VDD VDD VSS VSS gf180mcu_fd_sc_mcu7t5v0__fill_1
XFILLER_36_6 VDD VDD VSS VSS gf180mcu_fd_sc_mcu7t5v0__fill_1
XFILLER_36_92 VDD VDD VSS VSS gf180mcu_fd_sc_mcu7t5v0__fill_2
XFILLER_36_94 VDD VDD VSS VSS gf180mcu_fd_sc_mcu7t5v0__fill_1
XFILLER_37_100 VDD VDD VSS VSS gf180mcu_fd_sc_mcu7t5v0__fill_1
XFILLER_37_147 VDD VDD VSS VSS gf180mcu_fd_sc_mcu7t5v0__fill_2
XFILLER_37_183 VDD VDD VSS VSS gf180mcu_fd_sc_mcu7t5v0__fill_2
XFILLER_37_185 VDD VDD VSS VSS gf180mcu_fd_sc_mcu7t5v0__fill_1
XFILLER_37_197 VDD VDD VSS VSS gf180mcu_fd_sc_mcu7t5v0__fill_1
XFILLER_37_217 VDD VDD VSS VSS gf180mcu_fd_sc_mcu7t5v0__fill_1
XFILLER_37_252 VDD VDD VSS VSS gf180mcu_fd_sc_mcu7t5v0__fill_2
XFILLER_37_254 VDD VDD VSS VSS gf180mcu_fd_sc_mcu7t5v0__fill_1
XFILLER_37_282 VDD VDD VSS VSS gf180mcu_fd_sc_mcu7t5v0__fill_1
XFILLER_37_330 VDD VDD VSS VSS gf180mcu_fd_sc_mcu7t5v0__fill_1
XFILLER_37_349 VDD VDD VSS VSS gf180mcu_fd_sc_mcu7t5v0__fill_1
XFILLER_37_352 VDD VDD VSS VSS gf180mcu_fd_sc_mcu7t5v0__fill_2
XFILLER_37_354 VDD VDD VSS VSS gf180mcu_fd_sc_mcu7t5v0__fill_1
XFILLER_37_363 VDD VDD VSS VSS gf180mcu_fd_sc_mcu7t5v0__fill_1
XFILLER_37_68 VDD VDD VSS VSS gf180mcu_fd_sc_mcu7t5v0__fill_2
XFILLER_37_80 VDD VDD VSS VSS gf180mcu_fd_sc_mcu7t5v0__fill_1
XFILLER_38_107 VDD VDD VSS VSS gf180mcu_fd_sc_mcu7t5v0__fill_2
XFILLER_38_109 VDD VDD VSS VSS gf180mcu_fd_sc_mcu7t5v0__fill_1
XFILLER_38_160 VDD VDD VSS VSS gf180mcu_fd_sc_mcu7t5v0__fill_2
XFILLER_38_167 VDD VDD VSS VSS gf180mcu_fd_sc_mcu7t5v0__fill_2
XFILLER_38_169 VDD VDD VSS VSS gf180mcu_fd_sc_mcu7t5v0__fill_1
XFILLER_38_177 VDD VDD VSS VSS gf180mcu_fd_sc_mcu7t5v0__fill_1
XFILLER_38_190 VDD VDD VSS VSS gf180mcu_fd_sc_mcu7t5v0__fill_2
XFILLER_38_2 VDD VDD VSS VSS gf180mcu_fd_sc_mcu7t5v0__fillcap_4
XFILLER_38_233 VDD VDD VSS VSS gf180mcu_fd_sc_mcu7t5v0__fillcap_8
XFILLER_38_24 VDD VDD VSS VSS gf180mcu_fd_sc_mcu7t5v0__fill_1
XFILLER_38_317 VDD VDD VSS VSS gf180mcu_fd_sc_mcu7t5v0__fill_2
XFILLER_38_319 VDD VDD VSS VSS gf180mcu_fd_sc_mcu7t5v0__fill_1
XFILLER_38_326 VDD VDD VSS VSS gf180mcu_fd_sc_mcu7t5v0__fill_1
XFILLER_38_336 VDD VDD VSS VSS gf180mcu_fd_sc_mcu7t5v0__fill_2
XFILLER_38_37 VDD VDD VSS VSS gf180mcu_fd_sc_mcu7t5v0__fill_1
XFILLER_39_142 VDD VDD VSS VSS gf180mcu_fd_sc_mcu7t5v0__fillcap_4
XFILLER_39_146 VDD VDD VSS VSS gf180mcu_fd_sc_mcu7t5v0__fill_1
XFILLER_39_197 VDD VDD VSS VSS gf180mcu_fd_sc_mcu7t5v0__fillcap_4
XFILLER_39_201 VDD VDD VSS VSS gf180mcu_fd_sc_mcu7t5v0__fill_2
XFILLER_39_203 VDD VDD VSS VSS gf180mcu_fd_sc_mcu7t5v0__fill_1
XFILLER_39_216 VDD VDD VSS VSS gf180mcu_fd_sc_mcu7t5v0__fill_1
XFILLER_39_257 VDD VDD VSS VSS gf180mcu_fd_sc_mcu7t5v0__fill_1
XFILLER_39_298 VDD VDD VSS VSS gf180mcu_fd_sc_mcu7t5v0__fill_2
XFILLER_39_348 VDD VDD VSS VSS gf180mcu_fd_sc_mcu7t5v0__fill_2
XFILLER_39_352 VDD VDD VSS VSS gf180mcu_fd_sc_mcu7t5v0__fill_2
XFILLER_39_354 VDD VDD VSS VSS gf180mcu_fd_sc_mcu7t5v0__fill_1
XFILLER_39_36 VDD VDD VSS VSS gf180mcu_fd_sc_mcu7t5v0__fill_2
XFILLER_39_38 VDD VDD VSS VSS gf180mcu_fd_sc_mcu7t5v0__fill_1
XFILLER_39_46 VDD VDD VSS VSS gf180mcu_fd_sc_mcu7t5v0__fillcap_4
XFILLER_39_72 VDD VDD VSS VSS gf180mcu_fd_sc_mcu7t5v0__fill_1
XFILLER_3_105 VDD VDD VSS VSS gf180mcu_fd_sc_mcu7t5v0__fill_1
XFILLER_3_212 VDD VDD VSS VSS gf180mcu_fd_sc_mcu7t5v0__fill_1
XFILLER_3_236 VDD VDD VSS VSS gf180mcu_fd_sc_mcu7t5v0__fill_2
XFILLER_3_357 VDD VDD VSS VSS gf180mcu_fd_sc_mcu7t5v0__fill_2
XFILLER_3_381 VDD VDD VSS VSS gf180mcu_fd_sc_mcu7t5v0__fill_2
XFILLER_3_383 VDD VDD VSS VSS gf180mcu_fd_sc_mcu7t5v0__fill_1
XFILLER_3_72 VDD VDD VSS VSS gf180mcu_fd_sc_mcu7t5v0__fill_1
XFILLER_40_103 VDD VDD VSS VSS gf180mcu_fd_sc_mcu7t5v0__fill_2
XFILLER_40_130 VDD VDD VSS VSS gf180mcu_fd_sc_mcu7t5v0__fill_2
XFILLER_40_15 VDD VDD VSS VSS gf180mcu_fd_sc_mcu7t5v0__fillcap_4
XFILLER_40_166 VDD VDD VSS VSS gf180mcu_fd_sc_mcu7t5v0__fill_1
XFILLER_40_184 VDD VDD VSS VSS gf180mcu_fd_sc_mcu7t5v0__fill_2
XFILLER_40_19 VDD VDD VSS VSS gf180mcu_fd_sc_mcu7t5v0__fill_2
XFILLER_40_192 VDD VDD VSS VSS gf180mcu_fd_sc_mcu7t5v0__fill_2
XFILLER_40_2 VDD VDD VSS VSS gf180mcu_fd_sc_mcu7t5v0__fill_1
XFILLER_40_202 VDD VDD VSS VSS gf180mcu_fd_sc_mcu7t5v0__fill_2
XFILLER_40_204 VDD VDD VSS VSS gf180mcu_fd_sc_mcu7t5v0__fill_1
XFILLER_40_21 VDD VDD VSS VSS gf180mcu_fd_sc_mcu7t5v0__fill_1
XFILLER_40_239 VDD VDD VSS VSS gf180mcu_fd_sc_mcu7t5v0__fill_1
XFILLER_40_314 VDD VDD VSS VSS gf180mcu_fd_sc_mcu7t5v0__fill_1
XFILLER_40_347 VDD VDD VSS VSS gf180mcu_fd_sc_mcu7t5v0__fill_2
XFILLER_40_349 VDD VDD VSS VSS gf180mcu_fd_sc_mcu7t5v0__fill_1
XFILLER_41_17 VDD VDD VSS VSS gf180mcu_fd_sc_mcu7t5v0__fillcap_4
XFILLER_41_189 VDD VDD VSS VSS gf180mcu_fd_sc_mcu7t5v0__fill_1
XFILLER_41_2 VDD VDD VSS VSS gf180mcu_fd_sc_mcu7t5v0__fillcap_4
XFILLER_41_21 VDD VDD VSS VSS gf180mcu_fd_sc_mcu7t5v0__fill_2
XFILLER_41_212 VDD VDD VSS VSS gf180mcu_fd_sc_mcu7t5v0__fillcap_4
XFILLER_41_216 VDD VDD VSS VSS gf180mcu_fd_sc_mcu7t5v0__fill_2
XFILLER_41_218 VDD VDD VSS VSS gf180mcu_fd_sc_mcu7t5v0__fill_1
XFILLER_41_23 VDD VDD VSS VSS gf180mcu_fd_sc_mcu7t5v0__fill_1
XFILLER_41_290 VDD VDD VSS VSS gf180mcu_fd_sc_mcu7t5v0__fill_2
XFILLER_41_292 VDD VDD VSS VSS gf180mcu_fd_sc_mcu7t5v0__fill_1
XFILLER_41_6 VDD VDD VSS VSS gf180mcu_fd_sc_mcu7t5v0__fill_2
XFILLER_41_68 VDD VDD VSS VSS gf180mcu_fd_sc_mcu7t5v0__fill_2
XFILLER_41_72 VDD VDD VSS VSS gf180mcu_fd_sc_mcu7t5v0__fillcap_8
XFILLER_41_8 VDD VDD VSS VSS gf180mcu_fd_sc_mcu7t5v0__fill_1
XFILLER_41_80 VDD VDD VSS VSS gf180mcu_fd_sc_mcu7t5v0__fillcap_4
XFILLER_41_84 VDD VDD VSS VSS gf180mcu_fd_sc_mcu7t5v0__fill_1
XFILLER_42_102 VDD VDD VSS VSS gf180mcu_fd_sc_mcu7t5v0__fill_2
XFILLER_42_104 VDD VDD VSS VSS gf180mcu_fd_sc_mcu7t5v0__fill_1
XFILLER_42_107 VDD VDD VSS VSS gf180mcu_fd_sc_mcu7t5v0__fill_1
XFILLER_42_116 VDD VDD VSS VSS gf180mcu_fd_sc_mcu7t5v0__fillcap_4
XFILLER_42_120 VDD VDD VSS VSS gf180mcu_fd_sc_mcu7t5v0__fill_2
XFILLER_42_162 VDD VDD VSS VSS gf180mcu_fd_sc_mcu7t5v0__fillcap_4
XFILLER_42_170 VDD VDD VSS VSS gf180mcu_fd_sc_mcu7t5v0__fillcap_4
XFILLER_42_174 VDD VDD VSS VSS gf180mcu_fd_sc_mcu7t5v0__fill_1
XFILLER_42_177 VDD VDD VSS VSS gf180mcu_fd_sc_mcu7t5v0__fill_2
XFILLER_42_179 VDD VDD VSS VSS gf180mcu_fd_sc_mcu7t5v0__fill_1
XFILLER_42_2 VDD VDD VSS VSS gf180mcu_fd_sc_mcu7t5v0__fill_1
XFILLER_42_203 VDD VDD VSS VSS gf180mcu_fd_sc_mcu7t5v0__fill_2
XFILLER_42_239 VDD VDD VSS VSS gf180mcu_fd_sc_mcu7t5v0__fill_1
XFILLER_42_26 VDD VDD VSS VSS gf180mcu_fd_sc_mcu7t5v0__fill_2
XFILLER_42_333 VDD VDD VSS VSS gf180mcu_fd_sc_mcu7t5v0__fill_2
XFILLER_42_377 VDD VDD VSS VSS gf180mcu_fd_sc_mcu7t5v0__fillcap_4
XFILLER_42_381 VDD VDD VSS VSS gf180mcu_fd_sc_mcu7t5v0__fill_2
XFILLER_42_383 VDD VDD VSS VSS gf180mcu_fd_sc_mcu7t5v0__fill_1
XFILLER_42_45 VDD VDD VSS VSS gf180mcu_fd_sc_mcu7t5v0__fill_2
XFILLER_43_105 VDD VDD VSS VSS gf180mcu_fd_sc_mcu7t5v0__fill_2
XFILLER_43_189 VDD VDD VSS VSS gf180mcu_fd_sc_mcu7t5v0__fill_2
XFILLER_43_191 VDD VDD VSS VSS gf180mcu_fd_sc_mcu7t5v0__fill_1
XFILLER_43_197 VDD VDD VSS VSS gf180mcu_fd_sc_mcu7t5v0__fill_1
XFILLER_43_212 VDD VDD VSS VSS gf180mcu_fd_sc_mcu7t5v0__fillcap_8
XFILLER_43_277 VDD VDD VSS VSS gf180mcu_fd_sc_mcu7t5v0__fill_2
XFILLER_43_279 VDD VDD VSS VSS gf180mcu_fd_sc_mcu7t5v0__fill_1
XFILLER_43_288 VDD VDD VSS VSS gf180mcu_fd_sc_mcu7t5v0__fill_1
XFILLER_43_335 VDD VDD VSS VSS gf180mcu_fd_sc_mcu7t5v0__fill_1
XFILLER_43_348 VDD VDD VSS VSS gf180mcu_fd_sc_mcu7t5v0__fill_2
XFILLER_43_357 VDD VDD VSS VSS gf180mcu_fd_sc_mcu7t5v0__fill_2
XFILLER_43_36 VDD VDD VSS VSS gf180mcu_fd_sc_mcu7t5v0__fillcap_4
XFILLER_43_367 VDD VDD VSS VSS gf180mcu_fd_sc_mcu7t5v0__fill_1
XFILLER_43_48 VDD VDD VSS VSS gf180mcu_fd_sc_mcu7t5v0__fill_1
XFILLER_43_69 VDD VDD VSS VSS gf180mcu_fd_sc_mcu7t5v0__fill_1
XFILLER_43_72 VDD VDD VSS VSS gf180mcu_fd_sc_mcu7t5v0__fillcap_8
XFILLER_43_80 VDD VDD VSS VSS gf180mcu_fd_sc_mcu7t5v0__fillcap_4
XFILLER_43_95 VDD VDD VSS VSS gf180mcu_fd_sc_mcu7t5v0__fill_2
XFILLER_44_107 VDD VDD VSS VSS gf180mcu_fd_sc_mcu7t5v0__fill_2
XFILLER_44_140 VDD VDD VSS VSS gf180mcu_fd_sc_mcu7t5v0__fill_1
XFILLER_44_18 VDD VDD VSS VSS gf180mcu_fd_sc_mcu7t5v0__fillcap_16
XFILLER_44_183 VDD VDD VSS VSS gf180mcu_fd_sc_mcu7t5v0__fill_2
XFILLER_44_2 VDD VDD VSS VSS gf180mcu_fd_sc_mcu7t5v0__fillcap_4
XFILLER_44_34 VDD VDD VSS VSS gf180mcu_fd_sc_mcu7t5v0__fill_1
XFILLER_44_383 VDD VDD VSS VSS gf180mcu_fd_sc_mcu7t5v0__fill_1
XFILLER_44_56 VDD VDD VSS VSS gf180mcu_fd_sc_mcu7t5v0__fill_2
XFILLER_44_58 VDD VDD VSS VSS gf180mcu_fd_sc_mcu7t5v0__fill_1
XFILLER_44_82 VDD VDD VSS VSS gf180mcu_fd_sc_mcu7t5v0__fillcap_4
XFILLER_44_86 VDD VDD VSS VSS gf180mcu_fd_sc_mcu7t5v0__fill_1
XFILLER_45_125 VDD VDD VSS VSS gf180mcu_fd_sc_mcu7t5v0__fill_2
XFILLER_45_127 VDD VDD VSS VSS gf180mcu_fd_sc_mcu7t5v0__fill_1
XFILLER_45_198 VDD VDD VSS VSS gf180mcu_fd_sc_mcu7t5v0__fill_2
XFILLER_45_2 VDD VDD VSS VSS gf180mcu_fd_sc_mcu7t5v0__fill_2
XFILLER_45_278 VDD VDD VSS VSS gf180mcu_fd_sc_mcu7t5v0__fill_2
XFILLER_45_338 VDD VDD VSS VSS gf180mcu_fd_sc_mcu7t5v0__fill_2
XFILLER_45_340 VDD VDD VSS VSS gf180mcu_fd_sc_mcu7t5v0__fill_1
XFILLER_45_349 VDD VDD VSS VSS gf180mcu_fd_sc_mcu7t5v0__fill_1
XFILLER_45_352 VDD VDD VSS VSS gf180mcu_fd_sc_mcu7t5v0__fill_1
XFILLER_45_4 VDD VDD VSS VSS gf180mcu_fd_sc_mcu7t5v0__fill_1
XFILLER_45_63 VDD VDD VSS VSS gf180mcu_fd_sc_mcu7t5v0__fill_1
XFILLER_45_69 VDD VDD VSS VSS gf180mcu_fd_sc_mcu7t5v0__fill_1
XFILLER_46_103 VDD VDD VSS VSS gf180mcu_fd_sc_mcu7t5v0__fill_2
XFILLER_46_117 VDD VDD VSS VSS gf180mcu_fd_sc_mcu7t5v0__fill_2
XFILLER_46_166 VDD VDD VSS VSS gf180mcu_fd_sc_mcu7t5v0__fill_1
XFILLER_46_2 VDD VDD VSS VSS gf180mcu_fd_sc_mcu7t5v0__fill_2
XFILLER_46_208 VDD VDD VSS VSS gf180mcu_fd_sc_mcu7t5v0__fill_2
XFILLER_46_210 VDD VDD VSS VSS gf180mcu_fd_sc_mcu7t5v0__fill_1
XFILLER_46_23 VDD VDD VSS VSS gf180mcu_fd_sc_mcu7t5v0__fillcap_4
XFILLER_46_337 VDD VDD VSS VSS gf180mcu_fd_sc_mcu7t5v0__fill_1
XFILLER_46_66 VDD VDD VSS VSS gf180mcu_fd_sc_mcu7t5v0__fill_2
XFILLER_46_68 VDD VDD VSS VSS gf180mcu_fd_sc_mcu7t5v0__fill_1
XFILLER_47_196 VDD VDD VSS VSS gf180mcu_fd_sc_mcu7t5v0__fill_2
XFILLER_47_208 VDD VDD VSS VSS gf180mcu_fd_sc_mcu7t5v0__fill_2
XFILLER_47_218 VDD VDD VSS VSS gf180mcu_fd_sc_mcu7t5v0__fill_1
XFILLER_47_277 VDD VDD VSS VSS gf180mcu_fd_sc_mcu7t5v0__fill_2
XFILLER_47_279 VDD VDD VSS VSS gf180mcu_fd_sc_mcu7t5v0__fill_1
XFILLER_47_294 VDD VDD VSS VSS gf180mcu_fd_sc_mcu7t5v0__fill_2
XFILLER_47_352 VDD VDD VSS VSS gf180mcu_fd_sc_mcu7t5v0__fill_2
XFILLER_47_72 VDD VDD VSS VSS gf180mcu_fd_sc_mcu7t5v0__fill_2
XFILLER_47_74 VDD VDD VSS VSS gf180mcu_fd_sc_mcu7t5v0__fill_1
XFILLER_47_88 VDD VDD VSS VSS gf180mcu_fd_sc_mcu7t5v0__fillcap_4
XFILLER_47_92 VDD VDD VSS VSS gf180mcu_fd_sc_mcu7t5v0__fill_1
XFILLER_48_104 VDD VDD VSS VSS gf180mcu_fd_sc_mcu7t5v0__fill_1
XFILLER_48_131 VDD VDD VSS VSS gf180mcu_fd_sc_mcu7t5v0__fill_2
XFILLER_48_133 VDD VDD VSS VSS gf180mcu_fd_sc_mcu7t5v0__fill_1
XFILLER_48_168 VDD VDD VSS VSS gf180mcu_fd_sc_mcu7t5v0__fill_2
XFILLER_48_170 VDD VDD VSS VSS gf180mcu_fd_sc_mcu7t5v0__fill_1
XFILLER_48_206 VDD VDD VSS VSS gf180mcu_fd_sc_mcu7t5v0__fillcap_4
XFILLER_48_23 VDD VDD VSS VSS gf180mcu_fd_sc_mcu7t5v0__fillcap_4
XFILLER_48_244 VDD VDD VSS VSS gf180mcu_fd_sc_mcu7t5v0__fill_1
XFILLER_48_27 VDD VDD VSS VSS gf180mcu_fd_sc_mcu7t5v0__fill_2
XFILLER_48_29 VDD VDD VSS VSS gf180mcu_fd_sc_mcu7t5v0__fill_1
XFILLER_48_356 VDD VDD VSS VSS gf180mcu_fd_sc_mcu7t5v0__fill_1
XFILLER_48_37 VDD VDD VSS VSS gf180mcu_fd_sc_mcu7t5v0__fill_1
XFILLER_48_51 VDD VDD VSS VSS gf180mcu_fd_sc_mcu7t5v0__fill_2
XFILLER_48_53 VDD VDD VSS VSS gf180mcu_fd_sc_mcu7t5v0__fill_1
XFILLER_48_98 VDD VDD VSS VSS gf180mcu_fd_sc_mcu7t5v0__fill_1
XFILLER_49_104 VDD VDD VSS VSS gf180mcu_fd_sc_mcu7t5v0__fillcap_4
XFILLER_49_108 VDD VDD VSS VSS gf180mcu_fd_sc_mcu7t5v0__fill_1
XFILLER_49_125 VDD VDD VSS VSS gf180mcu_fd_sc_mcu7t5v0__fill_2
XFILLER_49_147 VDD VDD VSS VSS gf180mcu_fd_sc_mcu7t5v0__fill_2
XFILLER_49_153 VDD VDD VSS VSS gf180mcu_fd_sc_mcu7t5v0__fill_1
XFILLER_49_158 VDD VDD VSS VSS gf180mcu_fd_sc_mcu7t5v0__fillcap_8
XFILLER_49_17 VDD VDD VSS VSS gf180mcu_fd_sc_mcu7t5v0__fillcap_16
XFILLER_49_172 VDD VDD VSS VSS gf180mcu_fd_sc_mcu7t5v0__fillcap_16
XFILLER_49_188 VDD VDD VSS VSS gf180mcu_fd_sc_mcu7t5v0__fill_2
XFILLER_49_190 VDD VDD VSS VSS gf180mcu_fd_sc_mcu7t5v0__fill_1
XFILLER_49_2 VDD VDD VSS VSS gf180mcu_fd_sc_mcu7t5v0__fillcap_4
XFILLER_49_203 VDD VDD VSS VSS gf180mcu_fd_sc_mcu7t5v0__fill_1
XFILLER_49_212 VDD VDD VSS VSS gf180mcu_fd_sc_mcu7t5v0__fillcap_16
XFILLER_49_228 VDD VDD VSS VSS gf180mcu_fd_sc_mcu7t5v0__fillcap_4
XFILLER_49_232 VDD VDD VSS VSS gf180mcu_fd_sc_mcu7t5v0__fill_2
XFILLER_49_240 VDD VDD VSS VSS gf180mcu_fd_sc_mcu7t5v0__fill_2
XFILLER_49_271 VDD VDD VSS VSS gf180mcu_fd_sc_mcu7t5v0__fill_1
XFILLER_49_274 VDD VDD VSS VSS gf180mcu_fd_sc_mcu7t5v0__fill_1
XFILLER_49_322 VDD VDD VSS VSS gf180mcu_fd_sc_mcu7t5v0__fill_2
XFILLER_49_33 VDD VDD VSS VSS gf180mcu_fd_sc_mcu7t5v0__fill_1
XFILLER_49_337 VDD VDD VSS VSS gf180mcu_fd_sc_mcu7t5v0__fill_2
XFILLER_49_339 VDD VDD VSS VSS gf180mcu_fd_sc_mcu7t5v0__fill_1
XFILLER_49_357 VDD VDD VSS VSS gf180mcu_fd_sc_mcu7t5v0__fill_1
XFILLER_49_36 VDD VDD VSS VSS gf180mcu_fd_sc_mcu7t5v0__fillcap_4
XFILLER_49_376 VDD VDD VSS VSS gf180mcu_fd_sc_mcu7t5v0__fillcap_8
XFILLER_49_40 VDD VDD VSS VSS gf180mcu_fd_sc_mcu7t5v0__fill_2
XFILLER_49_42 VDD VDD VSS VSS gf180mcu_fd_sc_mcu7t5v0__fill_1
XFILLER_49_56 VDD VDD VSS VSS gf180mcu_fd_sc_mcu7t5v0__fill_1
XFILLER_49_6 VDD VDD VSS VSS gf180mcu_fd_sc_mcu7t5v0__fill_2
XFILLER_49_65 VDD VDD VSS VSS gf180mcu_fd_sc_mcu7t5v0__fill_2
XFILLER_49_67 VDD VDD VSS VSS gf180mcu_fd_sc_mcu7t5v0__fill_1
XFILLER_49_8 VDD VDD VSS VSS gf180mcu_fd_sc_mcu7t5v0__fill_1
XFILLER_49_87 VDD VDD VSS VSS gf180mcu_fd_sc_mcu7t5v0__fillcap_4
XFILLER_49_91 VDD VDD VSS VSS gf180mcu_fd_sc_mcu7t5v0__fill_2
XFILLER_49_93 VDD VDD VSS VSS gf180mcu_fd_sc_mcu7t5v0__fill_1
XFILLER_4_193 VDD VDD VSS VSS gf180mcu_fd_sc_mcu7t5v0__fill_1
XFILLER_4_20 VDD VDD VSS VSS gf180mcu_fd_sc_mcu7t5v0__fill_2
XFILLER_4_22 VDD VDD VSS VSS gf180mcu_fd_sc_mcu7t5v0__fill_1
XFILLER_4_242 VDD VDD VSS VSS gf180mcu_fd_sc_mcu7t5v0__fill_2
XFILLER_4_244 VDD VDD VSS VSS gf180mcu_fd_sc_mcu7t5v0__fill_1
XFILLER_4_247 VDD VDD VSS VSS gf180mcu_fd_sc_mcu7t5v0__fill_1
XFILLER_4_282 VDD VDD VSS VSS gf180mcu_fd_sc_mcu7t5v0__fill_1
XFILLER_4_369 VDD VDD VSS VSS gf180mcu_fd_sc_mcu7t5v0__fill_1
XFILLER_4_383 VDD VDD VSS VSS gf180mcu_fd_sc_mcu7t5v0__fill_1
XFILLER_5_199 VDD VDD VSS VSS gf180mcu_fd_sc_mcu7t5v0__fill_2
XFILLER_5_269 VDD VDD VSS VSS gf180mcu_fd_sc_mcu7t5v0__fill_2
XFILLER_5_357 VDD VDD VSS VSS gf180mcu_fd_sc_mcu7t5v0__fill_2
XFILLER_5_359 VDD VDD VSS VSS gf180mcu_fd_sc_mcu7t5v0__fill_1
XFILLER_5_381 VDD VDD VSS VSS gf180mcu_fd_sc_mcu7t5v0__fill_2
XFILLER_5_383 VDD VDD VSS VSS gf180mcu_fd_sc_mcu7t5v0__fill_1
XFILLER_6_252 VDD VDD VSS VSS gf180mcu_fd_sc_mcu7t5v0__fill_2
XFILLER_6_254 VDD VDD VSS VSS gf180mcu_fd_sc_mcu7t5v0__fill_1
XFILLER_6_303 VDD VDD VSS VSS gf180mcu_fd_sc_mcu7t5v0__fill_2
XFILLER_6_305 VDD VDD VSS VSS gf180mcu_fd_sc_mcu7t5v0__fill_1
XFILLER_6_345 VDD VDD VSS VSS gf180mcu_fd_sc_mcu7t5v0__fill_2
XFILLER_6_37 VDD VDD VSS VSS gf180mcu_fd_sc_mcu7t5v0__fill_2
XFILLER_6_381 VDD VDD VSS VSS gf180mcu_fd_sc_mcu7t5v0__fill_2
XFILLER_6_383 VDD VDD VSS VSS gf180mcu_fd_sc_mcu7t5v0__fill_1
XFILLER_6_39 VDD VDD VSS VSS gf180mcu_fd_sc_mcu7t5v0__fill_1
XFILLER_6_74 VDD VDD VSS VSS gf180mcu_fd_sc_mcu7t5v0__fill_1
XFILLER_6_98 VDD VDD VSS VSS gf180mcu_fd_sc_mcu7t5v0__fill_1
XFILLER_7_212 VDD VDD VSS VSS gf180mcu_fd_sc_mcu7t5v0__fill_2
XFILLER_7_214 VDD VDD VSS VSS gf180mcu_fd_sc_mcu7t5v0__fill_1
XFILLER_7_238 VDD VDD VSS VSS gf180mcu_fd_sc_mcu7t5v0__fill_2
XFILLER_8_119 VDD VDD VSS VSS gf180mcu_fd_sc_mcu7t5v0__fill_1
XFILLER_8_138 VDD VDD VSS VSS gf180mcu_fd_sc_mcu7t5v0__fill_2
XFILLER_8_140 VDD VDD VSS VSS gf180mcu_fd_sc_mcu7t5v0__fill_1
XFILLER_8_211 VDD VDD VSS VSS gf180mcu_fd_sc_mcu7t5v0__fill_2
XFILLER_8_312 VDD VDD VSS VSS gf180mcu_fd_sc_mcu7t5v0__fill_2
XFILLER_8_314 VDD VDD VSS VSS gf180mcu_fd_sc_mcu7t5v0__fill_1
XFILLER_8_71 VDD VDD VSS VSS gf180mcu_fd_sc_mcu7t5v0__fillcap_4
XFILLER_9_142 VDD VDD VSS VSS gf180mcu_fd_sc_mcu7t5v0__fill_1
XFILLER_9_169 VDD VDD VSS VSS gf180mcu_fd_sc_mcu7t5v0__fill_1
XFILLER_9_204 VDD VDD VSS VSS gf180mcu_fd_sc_mcu7t5v0__fill_1
XFILLER_9_212 VDD VDD VSS VSS gf180mcu_fd_sc_mcu7t5v0__fill_2
XFILLER_9_222 VDD VDD VSS VSS gf180mcu_fd_sc_mcu7t5v0__fill_1
XFILLER_9_362 VDD VDD VSS VSS gf180mcu_fd_sc_mcu7t5v0__fill_1
XFILLER_9_49 VDD VDD VSS VSS gf180mcu_fd_sc_mcu7t5v0__fill_2
XFILLER_9_69 VDD VDD VSS VSS gf180mcu_fd_sc_mcu7t5v0__fill_1
XFILLER_9_84 VDD VDD VSS VSS gf180mcu_fd_sc_mcu7t5v0__fill_2
XPHY_EDGE_ROW_0_Left_50 VDD NC_PHY_EDGE_ROW_0_Left_50_VNW NC_PHY_EDGE_ROW_0_Left_50_VPW VSS
+ gf180mcu_fd_sc_mcu7t5v0__endcap
XPHY_EDGE_ROW_0_Right_0 VDD NC_PHY_EDGE_ROW_0_Right_0_VNW NC_PHY_EDGE_ROW_0_Right_0_VPW VSS
+ gf180mcu_fd_sc_mcu7t5v0__endcap
XPHY_EDGE_ROW_10_Left_60 VDD NC_PHY_EDGE_ROW_10_Left_60_VNW NC_PHY_EDGE_ROW_10_Left_60_VPW VSS
+ gf180mcu_fd_sc_mcu7t5v0__endcap
XPHY_EDGE_ROW_10_Right_10 VDD NC_PHY_EDGE_ROW_10_Right_10_VNW NC_PHY_EDGE_ROW_10_Right_10_VPW VSS
+ gf180mcu_fd_sc_mcu7t5v0__endcap
XPHY_EDGE_ROW_11_Left_61 VDD NC_PHY_EDGE_ROW_11_Left_61_VNW NC_PHY_EDGE_ROW_11_Left_61_VPW VSS
+ gf180mcu_fd_sc_mcu7t5v0__endcap
XPHY_EDGE_ROW_11_Right_11 VDD NC_PHY_EDGE_ROW_11_Right_11_VNW NC_PHY_EDGE_ROW_11_Right_11_VPW VSS
+ gf180mcu_fd_sc_mcu7t5v0__endcap
XPHY_EDGE_ROW_12_Left_62 VDD NC_PHY_EDGE_ROW_12_Left_62_VNW NC_PHY_EDGE_ROW_12_Left_62_VPW VSS
+ gf180mcu_fd_sc_mcu7t5v0__endcap
XPHY_EDGE_ROW_12_Right_12 VDD NC_PHY_EDGE_ROW_12_Right_12_VNW NC_PHY_EDGE_ROW_12_Right_12_VPW VSS
+ gf180mcu_fd_sc_mcu7t5v0__endcap
XPHY_EDGE_ROW_13_Left_63 VDD NC_PHY_EDGE_ROW_13_Left_63_VNW NC_PHY_EDGE_ROW_13_Left_63_VPW VSS
+ gf180mcu_fd_sc_mcu7t5v0__endcap
XPHY_EDGE_ROW_13_Right_13 VDD NC_PHY_EDGE_ROW_13_Right_13_VNW NC_PHY_EDGE_ROW_13_Right_13_VPW VSS
+ gf180mcu_fd_sc_mcu7t5v0__endcap
XPHY_EDGE_ROW_14_Left_64 VDD NC_PHY_EDGE_ROW_14_Left_64_VNW NC_PHY_EDGE_ROW_14_Left_64_VPW VSS
+ gf180mcu_fd_sc_mcu7t5v0__endcap
XPHY_EDGE_ROW_14_Right_14 VDD NC_PHY_EDGE_ROW_14_Right_14_VNW NC_PHY_EDGE_ROW_14_Right_14_VPW VSS
+ gf180mcu_fd_sc_mcu7t5v0__endcap
XPHY_EDGE_ROW_15_Left_65 VDD NC_PHY_EDGE_ROW_15_Left_65_VNW NC_PHY_EDGE_ROW_15_Left_65_VPW VSS
+ gf180mcu_fd_sc_mcu7t5v0__endcap
XPHY_EDGE_ROW_15_Right_15 VDD NC_PHY_EDGE_ROW_15_Right_15_VNW NC_PHY_EDGE_ROW_15_Right_15_VPW VSS
+ gf180mcu_fd_sc_mcu7t5v0__endcap
XPHY_EDGE_ROW_16_Left_66 VDD NC_PHY_EDGE_ROW_16_Left_66_VNW NC_PHY_EDGE_ROW_16_Left_66_VPW VSS
+ gf180mcu_fd_sc_mcu7t5v0__endcap
XPHY_EDGE_ROW_16_Right_16 VDD NC_PHY_EDGE_ROW_16_Right_16_VNW NC_PHY_EDGE_ROW_16_Right_16_VPW VSS
+ gf180mcu_fd_sc_mcu7t5v0__endcap
XPHY_EDGE_ROW_17_Left_67 VDD NC_PHY_EDGE_ROW_17_Left_67_VNW NC_PHY_EDGE_ROW_17_Left_67_VPW VSS
+ gf180mcu_fd_sc_mcu7t5v0__endcap
XPHY_EDGE_ROW_17_Right_17 VDD NC_PHY_EDGE_ROW_17_Right_17_VNW NC_PHY_EDGE_ROW_17_Right_17_VPW VSS
+ gf180mcu_fd_sc_mcu7t5v0__endcap
XPHY_EDGE_ROW_18_Left_68 VDD NC_PHY_EDGE_ROW_18_Left_68_VNW NC_PHY_EDGE_ROW_18_Left_68_VPW VSS
+ gf180mcu_fd_sc_mcu7t5v0__endcap
XPHY_EDGE_ROW_18_Right_18 VDD NC_PHY_EDGE_ROW_18_Right_18_VNW NC_PHY_EDGE_ROW_18_Right_18_VPW VSS
+ gf180mcu_fd_sc_mcu7t5v0__endcap
XPHY_EDGE_ROW_19_Left_69 VDD NC_PHY_EDGE_ROW_19_Left_69_VNW NC_PHY_EDGE_ROW_19_Left_69_VPW VSS
+ gf180mcu_fd_sc_mcu7t5v0__endcap
XPHY_EDGE_ROW_19_Right_19 VDD NC_PHY_EDGE_ROW_19_Right_19_VNW NC_PHY_EDGE_ROW_19_Right_19_VPW VSS
+ gf180mcu_fd_sc_mcu7t5v0__endcap
XPHY_EDGE_ROW_1_Left_51 VDD NC_PHY_EDGE_ROW_1_Left_51_VNW NC_PHY_EDGE_ROW_1_Left_51_VPW VSS
+ gf180mcu_fd_sc_mcu7t5v0__endcap
XPHY_EDGE_ROW_1_Right_1 VDD NC_PHY_EDGE_ROW_1_Right_1_VNW NC_PHY_EDGE_ROW_1_Right_1_VPW VSS
+ gf180mcu_fd_sc_mcu7t5v0__endcap
XPHY_EDGE_ROW_20_Left_70 VDD NC_PHY_EDGE_ROW_20_Left_70_VNW NC_PHY_EDGE_ROW_20_Left_70_VPW VSS
+ gf180mcu_fd_sc_mcu7t5v0__endcap
XPHY_EDGE_ROW_20_Right_20 VDD NC_PHY_EDGE_ROW_20_Right_20_VNW NC_PHY_EDGE_ROW_20_Right_20_VPW VSS
+ gf180mcu_fd_sc_mcu7t5v0__endcap
XPHY_EDGE_ROW_21_Left_71 VDD NC_PHY_EDGE_ROW_21_Left_71_VNW NC_PHY_EDGE_ROW_21_Left_71_VPW VSS
+ gf180mcu_fd_sc_mcu7t5v0__endcap
XPHY_EDGE_ROW_21_Right_21 VDD NC_PHY_EDGE_ROW_21_Right_21_VNW NC_PHY_EDGE_ROW_21_Right_21_VPW VSS
+ gf180mcu_fd_sc_mcu7t5v0__endcap
XPHY_EDGE_ROW_22_Left_72 VDD NC_PHY_EDGE_ROW_22_Left_72_VNW NC_PHY_EDGE_ROW_22_Left_72_VPW VSS
+ gf180mcu_fd_sc_mcu7t5v0__endcap
XPHY_EDGE_ROW_22_Right_22 VDD NC_PHY_EDGE_ROW_22_Right_22_VNW NC_PHY_EDGE_ROW_22_Right_22_VPW VSS
+ gf180mcu_fd_sc_mcu7t5v0__endcap
XPHY_EDGE_ROW_23_Left_73 VDD NC_PHY_EDGE_ROW_23_Left_73_VNW NC_PHY_EDGE_ROW_23_Left_73_VPW VSS
+ gf180mcu_fd_sc_mcu7t5v0__endcap
XPHY_EDGE_ROW_23_Right_23 VDD NC_PHY_EDGE_ROW_23_Right_23_VNW NC_PHY_EDGE_ROW_23_Right_23_VPW VSS
+ gf180mcu_fd_sc_mcu7t5v0__endcap
XPHY_EDGE_ROW_24_Left_74 VDD NC_PHY_EDGE_ROW_24_Left_74_VNW NC_PHY_EDGE_ROW_24_Left_74_VPW VSS
+ gf180mcu_fd_sc_mcu7t5v0__endcap
XPHY_EDGE_ROW_24_Right_24 VDD NC_PHY_EDGE_ROW_24_Right_24_VNW NC_PHY_EDGE_ROW_24_Right_24_VPW VSS
+ gf180mcu_fd_sc_mcu7t5v0__endcap
XPHY_EDGE_ROW_25_Left_75 VDD NC_PHY_EDGE_ROW_25_Left_75_VNW NC_PHY_EDGE_ROW_25_Left_75_VPW VSS
+ gf180mcu_fd_sc_mcu7t5v0__endcap
XPHY_EDGE_ROW_25_Right_25 VDD NC_PHY_EDGE_ROW_25_Right_25_VNW NC_PHY_EDGE_ROW_25_Right_25_VPW VSS
+ gf180mcu_fd_sc_mcu7t5v0__endcap
XPHY_EDGE_ROW_26_Left_76 VDD NC_PHY_EDGE_ROW_26_Left_76_VNW NC_PHY_EDGE_ROW_26_Left_76_VPW VSS
+ gf180mcu_fd_sc_mcu7t5v0__endcap
XPHY_EDGE_ROW_26_Right_26 VDD NC_PHY_EDGE_ROW_26_Right_26_VNW NC_PHY_EDGE_ROW_26_Right_26_VPW VSS
+ gf180mcu_fd_sc_mcu7t5v0__endcap
XPHY_EDGE_ROW_27_Left_77 VDD NC_PHY_EDGE_ROW_27_Left_77_VNW NC_PHY_EDGE_ROW_27_Left_77_VPW VSS
+ gf180mcu_fd_sc_mcu7t5v0__endcap
XPHY_EDGE_ROW_27_Right_27 VDD NC_PHY_EDGE_ROW_27_Right_27_VNW NC_PHY_EDGE_ROW_27_Right_27_VPW VSS
+ gf180mcu_fd_sc_mcu7t5v0__endcap
XPHY_EDGE_ROW_28_Left_78 VDD NC_PHY_EDGE_ROW_28_Left_78_VNW NC_PHY_EDGE_ROW_28_Left_78_VPW VSS
+ gf180mcu_fd_sc_mcu7t5v0__endcap
XPHY_EDGE_ROW_28_Right_28 VDD NC_PHY_EDGE_ROW_28_Right_28_VNW NC_PHY_EDGE_ROW_28_Right_28_VPW VSS
+ gf180mcu_fd_sc_mcu7t5v0__endcap
XPHY_EDGE_ROW_29_Left_79 VDD NC_PHY_EDGE_ROW_29_Left_79_VNW NC_PHY_EDGE_ROW_29_Left_79_VPW VSS
+ gf180mcu_fd_sc_mcu7t5v0__endcap
XPHY_EDGE_ROW_29_Right_29 VDD NC_PHY_EDGE_ROW_29_Right_29_VNW NC_PHY_EDGE_ROW_29_Right_29_VPW VSS
+ gf180mcu_fd_sc_mcu7t5v0__endcap
XPHY_EDGE_ROW_2_Left_52 VDD NC_PHY_EDGE_ROW_2_Left_52_VNW NC_PHY_EDGE_ROW_2_Left_52_VPW VSS
+ gf180mcu_fd_sc_mcu7t5v0__endcap
XPHY_EDGE_ROW_2_Right_2 VDD NC_PHY_EDGE_ROW_2_Right_2_VNW NC_PHY_EDGE_ROW_2_Right_2_VPW VSS
+ gf180mcu_fd_sc_mcu7t5v0__endcap
XPHY_EDGE_ROW_30_Left_80 VDD NC_PHY_EDGE_ROW_30_Left_80_VNW NC_PHY_EDGE_ROW_30_Left_80_VPW VSS
+ gf180mcu_fd_sc_mcu7t5v0__endcap
XPHY_EDGE_ROW_30_Right_30 VDD NC_PHY_EDGE_ROW_30_Right_30_VNW NC_PHY_EDGE_ROW_30_Right_30_VPW VSS
+ gf180mcu_fd_sc_mcu7t5v0__endcap
XPHY_EDGE_ROW_31_Left_81 VDD NC_PHY_EDGE_ROW_31_Left_81_VNW NC_PHY_EDGE_ROW_31_Left_81_VPW VSS
+ gf180mcu_fd_sc_mcu7t5v0__endcap
XPHY_EDGE_ROW_31_Right_31 VDD NC_PHY_EDGE_ROW_31_Right_31_VNW NC_PHY_EDGE_ROW_31_Right_31_VPW VSS
+ gf180mcu_fd_sc_mcu7t5v0__endcap
XPHY_EDGE_ROW_32_Left_82 VDD NC_PHY_EDGE_ROW_32_Left_82_VNW NC_PHY_EDGE_ROW_32_Left_82_VPW VSS
+ gf180mcu_fd_sc_mcu7t5v0__endcap
XPHY_EDGE_ROW_32_Right_32 VDD NC_PHY_EDGE_ROW_32_Right_32_VNW NC_PHY_EDGE_ROW_32_Right_32_VPW VSS
+ gf180mcu_fd_sc_mcu7t5v0__endcap
XPHY_EDGE_ROW_33_Left_83 VDD NC_PHY_EDGE_ROW_33_Left_83_VNW NC_PHY_EDGE_ROW_33_Left_83_VPW VSS
+ gf180mcu_fd_sc_mcu7t5v0__endcap
XPHY_EDGE_ROW_33_Right_33 VDD NC_PHY_EDGE_ROW_33_Right_33_VNW NC_PHY_EDGE_ROW_33_Right_33_VPW VSS
+ gf180mcu_fd_sc_mcu7t5v0__endcap
XPHY_EDGE_ROW_34_Left_84 VDD NC_PHY_EDGE_ROW_34_Left_84_VNW NC_PHY_EDGE_ROW_34_Left_84_VPW VSS
+ gf180mcu_fd_sc_mcu7t5v0__endcap
XPHY_EDGE_ROW_34_Right_34 VDD NC_PHY_EDGE_ROW_34_Right_34_VNW NC_PHY_EDGE_ROW_34_Right_34_VPW VSS
+ gf180mcu_fd_sc_mcu7t5v0__endcap
XPHY_EDGE_ROW_35_Left_85 VDD NC_PHY_EDGE_ROW_35_Left_85_VNW NC_PHY_EDGE_ROW_35_Left_85_VPW VSS
+ gf180mcu_fd_sc_mcu7t5v0__endcap
XPHY_EDGE_ROW_35_Right_35 VDD NC_PHY_EDGE_ROW_35_Right_35_VNW NC_PHY_EDGE_ROW_35_Right_35_VPW VSS
+ gf180mcu_fd_sc_mcu7t5v0__endcap
XPHY_EDGE_ROW_36_Left_86 VDD NC_PHY_EDGE_ROW_36_Left_86_VNW NC_PHY_EDGE_ROW_36_Left_86_VPW VSS
+ gf180mcu_fd_sc_mcu7t5v0__endcap
XPHY_EDGE_ROW_36_Right_36 VDD NC_PHY_EDGE_ROW_36_Right_36_VNW NC_PHY_EDGE_ROW_36_Right_36_VPW VSS
+ gf180mcu_fd_sc_mcu7t5v0__endcap
XPHY_EDGE_ROW_37_Left_87 VDD NC_PHY_EDGE_ROW_37_Left_87_VNW NC_PHY_EDGE_ROW_37_Left_87_VPW VSS
+ gf180mcu_fd_sc_mcu7t5v0__endcap
XPHY_EDGE_ROW_37_Right_37 VDD NC_PHY_EDGE_ROW_37_Right_37_VNW NC_PHY_EDGE_ROW_37_Right_37_VPW VSS
+ gf180mcu_fd_sc_mcu7t5v0__endcap
XPHY_EDGE_ROW_38_Left_88 VDD NC_PHY_EDGE_ROW_38_Left_88_VNW NC_PHY_EDGE_ROW_38_Left_88_VPW VSS
+ gf180mcu_fd_sc_mcu7t5v0__endcap
XPHY_EDGE_ROW_38_Right_38 VDD NC_PHY_EDGE_ROW_38_Right_38_VNW NC_PHY_EDGE_ROW_38_Right_38_VPW VSS
+ gf180mcu_fd_sc_mcu7t5v0__endcap
XPHY_EDGE_ROW_39_Left_89 VDD NC_PHY_EDGE_ROW_39_Left_89_VNW NC_PHY_EDGE_ROW_39_Left_89_VPW VSS
+ gf180mcu_fd_sc_mcu7t5v0__endcap
XPHY_EDGE_ROW_39_Right_39 VDD NC_PHY_EDGE_ROW_39_Right_39_VNW NC_PHY_EDGE_ROW_39_Right_39_VPW VSS
+ gf180mcu_fd_sc_mcu7t5v0__endcap
XPHY_EDGE_ROW_3_Left_53 VDD NC_PHY_EDGE_ROW_3_Left_53_VNW NC_PHY_EDGE_ROW_3_Left_53_VPW VSS
+ gf180mcu_fd_sc_mcu7t5v0__endcap
XPHY_EDGE_ROW_3_Right_3 VDD NC_PHY_EDGE_ROW_3_Right_3_VNW NC_PHY_EDGE_ROW_3_Right_3_VPW VSS
+ gf180mcu_fd_sc_mcu7t5v0__endcap
XPHY_EDGE_ROW_40_Left_90 VDD NC_PHY_EDGE_ROW_40_Left_90_VNW NC_PHY_EDGE_ROW_40_Left_90_VPW VSS
+ gf180mcu_fd_sc_mcu7t5v0__endcap
XPHY_EDGE_ROW_40_Right_40 VDD NC_PHY_EDGE_ROW_40_Right_40_VNW NC_PHY_EDGE_ROW_40_Right_40_VPW VSS
+ gf180mcu_fd_sc_mcu7t5v0__endcap
XPHY_EDGE_ROW_41_Left_91 VDD NC_PHY_EDGE_ROW_41_Left_91_VNW NC_PHY_EDGE_ROW_41_Left_91_VPW VSS
+ gf180mcu_fd_sc_mcu7t5v0__endcap
XPHY_EDGE_ROW_41_Right_41 VDD NC_PHY_EDGE_ROW_41_Right_41_VNW NC_PHY_EDGE_ROW_41_Right_41_VPW VSS
+ gf180mcu_fd_sc_mcu7t5v0__endcap
XPHY_EDGE_ROW_42_Left_92 VDD NC_PHY_EDGE_ROW_42_Left_92_VNW NC_PHY_EDGE_ROW_42_Left_92_VPW VSS
+ gf180mcu_fd_sc_mcu7t5v0__endcap
XPHY_EDGE_ROW_42_Right_42 VDD NC_PHY_EDGE_ROW_42_Right_42_VNW NC_PHY_EDGE_ROW_42_Right_42_VPW VSS
+ gf180mcu_fd_sc_mcu7t5v0__endcap
XPHY_EDGE_ROW_43_Left_93 VDD NC_PHY_EDGE_ROW_43_Left_93_VNW NC_PHY_EDGE_ROW_43_Left_93_VPW VSS
+ gf180mcu_fd_sc_mcu7t5v0__endcap
XPHY_EDGE_ROW_43_Right_43 VDD NC_PHY_EDGE_ROW_43_Right_43_VNW NC_PHY_EDGE_ROW_43_Right_43_VPW VSS
+ gf180mcu_fd_sc_mcu7t5v0__endcap
XPHY_EDGE_ROW_44_Left_94 VDD NC_PHY_EDGE_ROW_44_Left_94_VNW NC_PHY_EDGE_ROW_44_Left_94_VPW VSS
+ gf180mcu_fd_sc_mcu7t5v0__endcap
XPHY_EDGE_ROW_44_Right_44 VDD NC_PHY_EDGE_ROW_44_Right_44_VNW NC_PHY_EDGE_ROW_44_Right_44_VPW VSS
+ gf180mcu_fd_sc_mcu7t5v0__endcap
XPHY_EDGE_ROW_45_Left_95 VDD NC_PHY_EDGE_ROW_45_Left_95_VNW NC_PHY_EDGE_ROW_45_Left_95_VPW VSS
+ gf180mcu_fd_sc_mcu7t5v0__endcap
XPHY_EDGE_ROW_45_Right_45 VDD NC_PHY_EDGE_ROW_45_Right_45_VNW NC_PHY_EDGE_ROW_45_Right_45_VPW VSS
+ gf180mcu_fd_sc_mcu7t5v0__endcap
XPHY_EDGE_ROW_46_Left_96 VDD NC_PHY_EDGE_ROW_46_Left_96_VNW NC_PHY_EDGE_ROW_46_Left_96_VPW VSS
+ gf180mcu_fd_sc_mcu7t5v0__endcap
XPHY_EDGE_ROW_46_Right_46 VDD NC_PHY_EDGE_ROW_46_Right_46_VNW NC_PHY_EDGE_ROW_46_Right_46_VPW VSS
+ gf180mcu_fd_sc_mcu7t5v0__endcap
XPHY_EDGE_ROW_47_Left_97 VDD NC_PHY_EDGE_ROW_47_Left_97_VNW NC_PHY_EDGE_ROW_47_Left_97_VPW VSS
+ gf180mcu_fd_sc_mcu7t5v0__endcap
XPHY_EDGE_ROW_47_Right_47 VDD NC_PHY_EDGE_ROW_47_Right_47_VNW NC_PHY_EDGE_ROW_47_Right_47_VPW VSS
+ gf180mcu_fd_sc_mcu7t5v0__endcap
XPHY_EDGE_ROW_48_Left_98 VDD NC_PHY_EDGE_ROW_48_Left_98_VNW NC_PHY_EDGE_ROW_48_Left_98_VPW VSS
+ gf180mcu_fd_sc_mcu7t5v0__endcap
XPHY_EDGE_ROW_48_Right_48 VDD NC_PHY_EDGE_ROW_48_Right_48_VNW NC_PHY_EDGE_ROW_48_Right_48_VPW VSS
+ gf180mcu_fd_sc_mcu7t5v0__endcap
XPHY_EDGE_ROW_49_Left_99 VDD NC_PHY_EDGE_ROW_49_Left_99_VNW NC_PHY_EDGE_ROW_49_Left_99_VPW VSS
+ gf180mcu_fd_sc_mcu7t5v0__endcap
XPHY_EDGE_ROW_49_Right_49 VDD NC_PHY_EDGE_ROW_49_Right_49_VNW NC_PHY_EDGE_ROW_49_Right_49_VPW VSS
+ gf180mcu_fd_sc_mcu7t5v0__endcap
XPHY_EDGE_ROW_4_Left_54 VDD NC_PHY_EDGE_ROW_4_Left_54_VNW NC_PHY_EDGE_ROW_4_Left_54_VPW VSS
+ gf180mcu_fd_sc_mcu7t5v0__endcap
XPHY_EDGE_ROW_4_Right_4 VDD NC_PHY_EDGE_ROW_4_Right_4_VNW NC_PHY_EDGE_ROW_4_Right_4_VPW VSS
+ gf180mcu_fd_sc_mcu7t5v0__endcap
XPHY_EDGE_ROW_5_Left_55 VDD NC_PHY_EDGE_ROW_5_Left_55_VNW NC_PHY_EDGE_ROW_5_Left_55_VPW VSS
+ gf180mcu_fd_sc_mcu7t5v0__endcap
XPHY_EDGE_ROW_5_Right_5 VDD NC_PHY_EDGE_ROW_5_Right_5_VNW NC_PHY_EDGE_ROW_5_Right_5_VPW VSS
+ gf180mcu_fd_sc_mcu7t5v0__endcap
XPHY_EDGE_ROW_6_Left_56 VDD NC_PHY_EDGE_ROW_6_Left_56_VNW NC_PHY_EDGE_ROW_6_Left_56_VPW VSS
+ gf180mcu_fd_sc_mcu7t5v0__endcap
XPHY_EDGE_ROW_6_Right_6 VDD NC_PHY_EDGE_ROW_6_Right_6_VNW NC_PHY_EDGE_ROW_6_Right_6_VPW VSS
+ gf180mcu_fd_sc_mcu7t5v0__endcap
XPHY_EDGE_ROW_7_Left_57 VDD NC_PHY_EDGE_ROW_7_Left_57_VNW NC_PHY_EDGE_ROW_7_Left_57_VPW VSS
+ gf180mcu_fd_sc_mcu7t5v0__endcap
XPHY_EDGE_ROW_7_Right_7 VDD NC_PHY_EDGE_ROW_7_Right_7_VNW NC_PHY_EDGE_ROW_7_Right_7_VPW VSS
+ gf180mcu_fd_sc_mcu7t5v0__endcap
XPHY_EDGE_ROW_8_Left_58 VDD NC_PHY_EDGE_ROW_8_Left_58_VNW NC_PHY_EDGE_ROW_8_Left_58_VPW VSS
+ gf180mcu_fd_sc_mcu7t5v0__endcap
XPHY_EDGE_ROW_8_Right_8 VDD NC_PHY_EDGE_ROW_8_Right_8_VNW NC_PHY_EDGE_ROW_8_Right_8_VPW VSS
+ gf180mcu_fd_sc_mcu7t5v0__endcap
XPHY_EDGE_ROW_9_Left_59 VDD NC_PHY_EDGE_ROW_9_Left_59_VNW NC_PHY_EDGE_ROW_9_Left_59_VPW VSS
+ gf180mcu_fd_sc_mcu7t5v0__endcap
XPHY_EDGE_ROW_9_Right_9 VDD NC_PHY_EDGE_ROW_9_Right_9_VNW NC_PHY_EDGE_ROW_9_Right_9_VPW VSS
+ gf180mcu_fd_sc_mcu7t5v0__endcap
XTAP_TAPCELL_ROW_0_100 VDD VSS gf180mcu_fd_sc_mcu7t5v0__filltie
XTAP_TAPCELL_ROW_0_101 VDD VSS gf180mcu_fd_sc_mcu7t5v0__filltie
XTAP_TAPCELL_ROW_0_102 VDD VSS gf180mcu_fd_sc_mcu7t5v0__filltie
XTAP_TAPCELL_ROW_0_103 VDD VSS gf180mcu_fd_sc_mcu7t5v0__filltie
XTAP_TAPCELL_ROW_0_104 VDD VSS gf180mcu_fd_sc_mcu7t5v0__filltie
XTAP_TAPCELL_ROW_0_105 VDD VSS gf180mcu_fd_sc_mcu7t5v0__filltie
XTAP_TAPCELL_ROW_0_106 VDD VSS gf180mcu_fd_sc_mcu7t5v0__filltie
XTAP_TAPCELL_ROW_0_107 VDD VSS gf180mcu_fd_sc_mcu7t5v0__filltie
XTAP_TAPCELL_ROW_0_108 VDD VSS gf180mcu_fd_sc_mcu7t5v0__filltie
XTAP_TAPCELL_ROW_0_109 VDD VSS gf180mcu_fd_sc_mcu7t5v0__filltie
XTAP_TAPCELL_ROW_0_110 VDD VSS gf180mcu_fd_sc_mcu7t5v0__filltie
XTAP_TAPCELL_ROW_10_156 VDD VSS gf180mcu_fd_sc_mcu7t5v0__filltie
XTAP_TAPCELL_ROW_10_157 VDD VSS gf180mcu_fd_sc_mcu7t5v0__filltie
XTAP_TAPCELL_ROW_10_158 VDD VSS gf180mcu_fd_sc_mcu7t5v0__filltie
XTAP_TAPCELL_ROW_10_159 VDD VSS gf180mcu_fd_sc_mcu7t5v0__filltie
XTAP_TAPCELL_ROW_10_160 VDD VSS gf180mcu_fd_sc_mcu7t5v0__filltie
XTAP_TAPCELL_ROW_11_161 VDD VSS gf180mcu_fd_sc_mcu7t5v0__filltie
XTAP_TAPCELL_ROW_11_162 VDD VSS gf180mcu_fd_sc_mcu7t5v0__filltie
XTAP_TAPCELL_ROW_11_163 VDD VSS gf180mcu_fd_sc_mcu7t5v0__filltie
XTAP_TAPCELL_ROW_11_164 VDD VSS gf180mcu_fd_sc_mcu7t5v0__filltie
XTAP_TAPCELL_ROW_11_165 VDD VSS gf180mcu_fd_sc_mcu7t5v0__filltie
XTAP_TAPCELL_ROW_12_166 VDD VSS gf180mcu_fd_sc_mcu7t5v0__filltie
XTAP_TAPCELL_ROW_12_167 VDD VSS gf180mcu_fd_sc_mcu7t5v0__filltie
XTAP_TAPCELL_ROW_12_168 VDD VSS gf180mcu_fd_sc_mcu7t5v0__filltie
XTAP_TAPCELL_ROW_12_169 VDD VSS gf180mcu_fd_sc_mcu7t5v0__filltie
XTAP_TAPCELL_ROW_12_170 VDD VSS gf180mcu_fd_sc_mcu7t5v0__filltie
XTAP_TAPCELL_ROW_13_171 VDD VSS gf180mcu_fd_sc_mcu7t5v0__filltie
XTAP_TAPCELL_ROW_13_172 VDD VSS gf180mcu_fd_sc_mcu7t5v0__filltie
XTAP_TAPCELL_ROW_13_173 VDD VSS gf180mcu_fd_sc_mcu7t5v0__filltie
XTAP_TAPCELL_ROW_13_174 VDD VSS gf180mcu_fd_sc_mcu7t5v0__filltie
XTAP_TAPCELL_ROW_13_175 VDD VSS gf180mcu_fd_sc_mcu7t5v0__filltie
XTAP_TAPCELL_ROW_14_176 VDD VSS gf180mcu_fd_sc_mcu7t5v0__filltie
XTAP_TAPCELL_ROW_14_177 VDD VSS gf180mcu_fd_sc_mcu7t5v0__filltie
XTAP_TAPCELL_ROW_14_178 VDD VSS gf180mcu_fd_sc_mcu7t5v0__filltie
XTAP_TAPCELL_ROW_14_179 VDD VSS gf180mcu_fd_sc_mcu7t5v0__filltie
XTAP_TAPCELL_ROW_14_180 VDD VSS gf180mcu_fd_sc_mcu7t5v0__filltie
XTAP_TAPCELL_ROW_15_181 VDD VSS gf180mcu_fd_sc_mcu7t5v0__filltie
XTAP_TAPCELL_ROW_15_182 VDD VSS gf180mcu_fd_sc_mcu7t5v0__filltie
XTAP_TAPCELL_ROW_15_183 VDD VSS gf180mcu_fd_sc_mcu7t5v0__filltie
XTAP_TAPCELL_ROW_15_184 VDD VSS gf180mcu_fd_sc_mcu7t5v0__filltie
XTAP_TAPCELL_ROW_15_185 VDD VSS gf180mcu_fd_sc_mcu7t5v0__filltie
XTAP_TAPCELL_ROW_16_186 VDD VSS gf180mcu_fd_sc_mcu7t5v0__filltie
XTAP_TAPCELL_ROW_16_187 VDD VSS gf180mcu_fd_sc_mcu7t5v0__filltie
XTAP_TAPCELL_ROW_16_188 VDD VSS gf180mcu_fd_sc_mcu7t5v0__filltie
XTAP_TAPCELL_ROW_16_189 VDD VSS gf180mcu_fd_sc_mcu7t5v0__filltie
XTAP_TAPCELL_ROW_16_190 VDD VSS gf180mcu_fd_sc_mcu7t5v0__filltie
XTAP_TAPCELL_ROW_17_191 VDD VSS gf180mcu_fd_sc_mcu7t5v0__filltie
XTAP_TAPCELL_ROW_17_192 VDD VSS gf180mcu_fd_sc_mcu7t5v0__filltie
XTAP_TAPCELL_ROW_17_193 VDD VSS gf180mcu_fd_sc_mcu7t5v0__filltie
XTAP_TAPCELL_ROW_17_194 VDD VSS gf180mcu_fd_sc_mcu7t5v0__filltie
XTAP_TAPCELL_ROW_17_195 VDD VSS gf180mcu_fd_sc_mcu7t5v0__filltie
XTAP_TAPCELL_ROW_18_196 VDD VSS gf180mcu_fd_sc_mcu7t5v0__filltie
XTAP_TAPCELL_ROW_18_197 VDD VSS gf180mcu_fd_sc_mcu7t5v0__filltie
XTAP_TAPCELL_ROW_18_198 VDD VSS gf180mcu_fd_sc_mcu7t5v0__filltie
XTAP_TAPCELL_ROW_18_199 VDD VSS gf180mcu_fd_sc_mcu7t5v0__filltie
XTAP_TAPCELL_ROW_18_200 VDD VSS gf180mcu_fd_sc_mcu7t5v0__filltie
XTAP_TAPCELL_ROW_19_201 VDD VSS gf180mcu_fd_sc_mcu7t5v0__filltie
XTAP_TAPCELL_ROW_19_202 VDD VSS gf180mcu_fd_sc_mcu7t5v0__filltie
XTAP_TAPCELL_ROW_19_203 VDD VSS gf180mcu_fd_sc_mcu7t5v0__filltie
XTAP_TAPCELL_ROW_19_204 VDD VSS gf180mcu_fd_sc_mcu7t5v0__filltie
XTAP_TAPCELL_ROW_19_205 VDD VSS gf180mcu_fd_sc_mcu7t5v0__filltie
XTAP_TAPCELL_ROW_1_111 VDD VSS gf180mcu_fd_sc_mcu7t5v0__filltie
XTAP_TAPCELL_ROW_1_112 VDD VSS gf180mcu_fd_sc_mcu7t5v0__filltie
XTAP_TAPCELL_ROW_1_113 VDD VSS gf180mcu_fd_sc_mcu7t5v0__filltie
XTAP_TAPCELL_ROW_1_114 VDD VSS gf180mcu_fd_sc_mcu7t5v0__filltie
XTAP_TAPCELL_ROW_1_115 VDD VSS gf180mcu_fd_sc_mcu7t5v0__filltie
XTAP_TAPCELL_ROW_20_206 VDD VSS gf180mcu_fd_sc_mcu7t5v0__filltie
XTAP_TAPCELL_ROW_20_207 VDD VSS gf180mcu_fd_sc_mcu7t5v0__filltie
XTAP_TAPCELL_ROW_20_208 VDD VSS gf180mcu_fd_sc_mcu7t5v0__filltie
XTAP_TAPCELL_ROW_20_209 VDD VSS gf180mcu_fd_sc_mcu7t5v0__filltie
XTAP_TAPCELL_ROW_20_210 VDD VSS gf180mcu_fd_sc_mcu7t5v0__filltie
XTAP_TAPCELL_ROW_21_211 VDD VSS gf180mcu_fd_sc_mcu7t5v0__filltie
XTAP_TAPCELL_ROW_21_212 VDD VSS gf180mcu_fd_sc_mcu7t5v0__filltie
XTAP_TAPCELL_ROW_21_213 VDD VSS gf180mcu_fd_sc_mcu7t5v0__filltie
XTAP_TAPCELL_ROW_21_214 VDD VSS gf180mcu_fd_sc_mcu7t5v0__filltie
XTAP_TAPCELL_ROW_21_215 VDD VSS gf180mcu_fd_sc_mcu7t5v0__filltie
XTAP_TAPCELL_ROW_22_216 VDD VSS gf180mcu_fd_sc_mcu7t5v0__filltie
XTAP_TAPCELL_ROW_22_217 VDD VSS gf180mcu_fd_sc_mcu7t5v0__filltie
XTAP_TAPCELL_ROW_22_218 VDD VSS gf180mcu_fd_sc_mcu7t5v0__filltie
XTAP_TAPCELL_ROW_22_219 VDD VSS gf180mcu_fd_sc_mcu7t5v0__filltie
XTAP_TAPCELL_ROW_22_220 VDD VSS gf180mcu_fd_sc_mcu7t5v0__filltie
XTAP_TAPCELL_ROW_23_221 VDD VSS gf180mcu_fd_sc_mcu7t5v0__filltie
XTAP_TAPCELL_ROW_23_222 VDD VSS gf180mcu_fd_sc_mcu7t5v0__filltie
XTAP_TAPCELL_ROW_23_223 VDD VSS gf180mcu_fd_sc_mcu7t5v0__filltie
XTAP_TAPCELL_ROW_23_224 VDD VSS gf180mcu_fd_sc_mcu7t5v0__filltie
XTAP_TAPCELL_ROW_23_225 VDD VSS gf180mcu_fd_sc_mcu7t5v0__filltie
XTAP_TAPCELL_ROW_24_226 VDD VSS gf180mcu_fd_sc_mcu7t5v0__filltie
XTAP_TAPCELL_ROW_24_227 VDD VSS gf180mcu_fd_sc_mcu7t5v0__filltie
XTAP_TAPCELL_ROW_24_228 VDD VSS gf180mcu_fd_sc_mcu7t5v0__filltie
XTAP_TAPCELL_ROW_24_229 VDD VSS gf180mcu_fd_sc_mcu7t5v0__filltie
XTAP_TAPCELL_ROW_24_230 VDD VSS gf180mcu_fd_sc_mcu7t5v0__filltie
XTAP_TAPCELL_ROW_25_231 VDD VSS gf180mcu_fd_sc_mcu7t5v0__filltie
XTAP_TAPCELL_ROW_25_232 VDD VSS gf180mcu_fd_sc_mcu7t5v0__filltie
XTAP_TAPCELL_ROW_25_233 VDD VSS gf180mcu_fd_sc_mcu7t5v0__filltie
XTAP_TAPCELL_ROW_25_234 VDD VSS gf180mcu_fd_sc_mcu7t5v0__filltie
XTAP_TAPCELL_ROW_25_235 VDD VSS gf180mcu_fd_sc_mcu7t5v0__filltie
XTAP_TAPCELL_ROW_26_236 VDD VSS gf180mcu_fd_sc_mcu7t5v0__filltie
XTAP_TAPCELL_ROW_26_237 VDD VSS gf180mcu_fd_sc_mcu7t5v0__filltie
XTAP_TAPCELL_ROW_26_238 VDD VSS gf180mcu_fd_sc_mcu7t5v0__filltie
XTAP_TAPCELL_ROW_26_239 VDD VSS gf180mcu_fd_sc_mcu7t5v0__filltie
XTAP_TAPCELL_ROW_26_240 VDD VSS gf180mcu_fd_sc_mcu7t5v0__filltie
XTAP_TAPCELL_ROW_27_241 VDD VSS gf180mcu_fd_sc_mcu7t5v0__filltie
XTAP_TAPCELL_ROW_27_242 VDD VSS gf180mcu_fd_sc_mcu7t5v0__filltie
XTAP_TAPCELL_ROW_27_243 VDD VSS gf180mcu_fd_sc_mcu7t5v0__filltie
XTAP_TAPCELL_ROW_27_244 VDD VSS gf180mcu_fd_sc_mcu7t5v0__filltie
XTAP_TAPCELL_ROW_27_245 VDD VSS gf180mcu_fd_sc_mcu7t5v0__filltie
XTAP_TAPCELL_ROW_28_246 VDD VSS gf180mcu_fd_sc_mcu7t5v0__filltie
XTAP_TAPCELL_ROW_28_247 VDD VSS gf180mcu_fd_sc_mcu7t5v0__filltie
XTAP_TAPCELL_ROW_28_248 VDD VSS gf180mcu_fd_sc_mcu7t5v0__filltie
XTAP_TAPCELL_ROW_28_249 VDD VSS gf180mcu_fd_sc_mcu7t5v0__filltie
XTAP_TAPCELL_ROW_28_250 VDD VSS gf180mcu_fd_sc_mcu7t5v0__filltie
XTAP_TAPCELL_ROW_29_251 VDD VSS gf180mcu_fd_sc_mcu7t5v0__filltie
XTAP_TAPCELL_ROW_29_252 VDD VSS gf180mcu_fd_sc_mcu7t5v0__filltie
XTAP_TAPCELL_ROW_29_253 VDD VSS gf180mcu_fd_sc_mcu7t5v0__filltie
XTAP_TAPCELL_ROW_29_254 VDD VSS gf180mcu_fd_sc_mcu7t5v0__filltie
XTAP_TAPCELL_ROW_29_255 VDD VSS gf180mcu_fd_sc_mcu7t5v0__filltie
XTAP_TAPCELL_ROW_2_116 VDD VSS gf180mcu_fd_sc_mcu7t5v0__filltie
XTAP_TAPCELL_ROW_2_117 VDD VSS gf180mcu_fd_sc_mcu7t5v0__filltie
XTAP_TAPCELL_ROW_2_118 VDD VSS gf180mcu_fd_sc_mcu7t5v0__filltie
XTAP_TAPCELL_ROW_2_119 VDD VSS gf180mcu_fd_sc_mcu7t5v0__filltie
XTAP_TAPCELL_ROW_2_120 VDD VSS gf180mcu_fd_sc_mcu7t5v0__filltie
XTAP_TAPCELL_ROW_30_256 VDD VSS gf180mcu_fd_sc_mcu7t5v0__filltie
XTAP_TAPCELL_ROW_30_257 VDD VSS gf180mcu_fd_sc_mcu7t5v0__filltie
XTAP_TAPCELL_ROW_30_258 VDD VSS gf180mcu_fd_sc_mcu7t5v0__filltie
XTAP_TAPCELL_ROW_30_259 VDD VSS gf180mcu_fd_sc_mcu7t5v0__filltie
XTAP_TAPCELL_ROW_30_260 VDD VSS gf180mcu_fd_sc_mcu7t5v0__filltie
XTAP_TAPCELL_ROW_31_261 VDD VSS gf180mcu_fd_sc_mcu7t5v0__filltie
XTAP_TAPCELL_ROW_31_262 VDD VSS gf180mcu_fd_sc_mcu7t5v0__filltie
XTAP_TAPCELL_ROW_31_263 VDD VSS gf180mcu_fd_sc_mcu7t5v0__filltie
XTAP_TAPCELL_ROW_31_264 VDD VSS gf180mcu_fd_sc_mcu7t5v0__filltie
XTAP_TAPCELL_ROW_31_265 VDD VSS gf180mcu_fd_sc_mcu7t5v0__filltie
XTAP_TAPCELL_ROW_32_266 VDD VSS gf180mcu_fd_sc_mcu7t5v0__filltie
XTAP_TAPCELL_ROW_32_267 VDD VSS gf180mcu_fd_sc_mcu7t5v0__filltie
XTAP_TAPCELL_ROW_32_268 VDD VSS gf180mcu_fd_sc_mcu7t5v0__filltie
XTAP_TAPCELL_ROW_32_269 VDD VSS gf180mcu_fd_sc_mcu7t5v0__filltie
XTAP_TAPCELL_ROW_32_270 VDD VSS gf180mcu_fd_sc_mcu7t5v0__filltie
XTAP_TAPCELL_ROW_33_271 VDD VSS gf180mcu_fd_sc_mcu7t5v0__filltie
XTAP_TAPCELL_ROW_33_272 VDD VSS gf180mcu_fd_sc_mcu7t5v0__filltie
XTAP_TAPCELL_ROW_33_273 VDD VSS gf180mcu_fd_sc_mcu7t5v0__filltie
XTAP_TAPCELL_ROW_33_274 VDD VSS gf180mcu_fd_sc_mcu7t5v0__filltie
XTAP_TAPCELL_ROW_33_275 VDD VSS gf180mcu_fd_sc_mcu7t5v0__filltie
XTAP_TAPCELL_ROW_34_276 VDD VSS gf180mcu_fd_sc_mcu7t5v0__filltie
XTAP_TAPCELL_ROW_34_277 VDD VSS gf180mcu_fd_sc_mcu7t5v0__filltie
XTAP_TAPCELL_ROW_34_278 VDD VSS gf180mcu_fd_sc_mcu7t5v0__filltie
XTAP_TAPCELL_ROW_34_279 VDD VSS gf180mcu_fd_sc_mcu7t5v0__filltie
XTAP_TAPCELL_ROW_34_280 VDD VSS gf180mcu_fd_sc_mcu7t5v0__filltie
XTAP_TAPCELL_ROW_35_281 VDD VSS gf180mcu_fd_sc_mcu7t5v0__filltie
XTAP_TAPCELL_ROW_35_282 VDD VSS gf180mcu_fd_sc_mcu7t5v0__filltie
XTAP_TAPCELL_ROW_35_283 VDD VSS gf180mcu_fd_sc_mcu7t5v0__filltie
XTAP_TAPCELL_ROW_35_284 VDD VSS gf180mcu_fd_sc_mcu7t5v0__filltie
XTAP_TAPCELL_ROW_35_285 VDD VSS gf180mcu_fd_sc_mcu7t5v0__filltie
XTAP_TAPCELL_ROW_36_286 VDD VSS gf180mcu_fd_sc_mcu7t5v0__filltie
XTAP_TAPCELL_ROW_36_287 VDD VSS gf180mcu_fd_sc_mcu7t5v0__filltie
XTAP_TAPCELL_ROW_36_288 VDD VSS gf180mcu_fd_sc_mcu7t5v0__filltie
XTAP_TAPCELL_ROW_36_289 VDD VSS gf180mcu_fd_sc_mcu7t5v0__filltie
XTAP_TAPCELL_ROW_36_290 VDD VSS gf180mcu_fd_sc_mcu7t5v0__filltie
XTAP_TAPCELL_ROW_37_291 VDD VSS gf180mcu_fd_sc_mcu7t5v0__filltie
XTAP_TAPCELL_ROW_37_292 VDD VSS gf180mcu_fd_sc_mcu7t5v0__filltie
XTAP_TAPCELL_ROW_37_293 VDD VSS gf180mcu_fd_sc_mcu7t5v0__filltie
XTAP_TAPCELL_ROW_37_294 VDD VSS gf180mcu_fd_sc_mcu7t5v0__filltie
XTAP_TAPCELL_ROW_37_295 VDD VSS gf180mcu_fd_sc_mcu7t5v0__filltie
XTAP_TAPCELL_ROW_38_296 VDD VSS gf180mcu_fd_sc_mcu7t5v0__filltie
XTAP_TAPCELL_ROW_38_297 VDD VSS gf180mcu_fd_sc_mcu7t5v0__filltie
XTAP_TAPCELL_ROW_38_298 VDD VSS gf180mcu_fd_sc_mcu7t5v0__filltie
XTAP_TAPCELL_ROW_38_299 VDD VSS gf180mcu_fd_sc_mcu7t5v0__filltie
XTAP_TAPCELL_ROW_38_300 VDD VSS gf180mcu_fd_sc_mcu7t5v0__filltie
XTAP_TAPCELL_ROW_39_301 VDD VSS gf180mcu_fd_sc_mcu7t5v0__filltie
XTAP_TAPCELL_ROW_39_302 VDD VSS gf180mcu_fd_sc_mcu7t5v0__filltie
XTAP_TAPCELL_ROW_39_303 VDD VSS gf180mcu_fd_sc_mcu7t5v0__filltie
XTAP_TAPCELL_ROW_39_304 VDD VSS gf180mcu_fd_sc_mcu7t5v0__filltie
XTAP_TAPCELL_ROW_39_305 VDD VSS gf180mcu_fd_sc_mcu7t5v0__filltie
XTAP_TAPCELL_ROW_3_121 VDD VSS gf180mcu_fd_sc_mcu7t5v0__filltie
XTAP_TAPCELL_ROW_3_122 VDD VSS gf180mcu_fd_sc_mcu7t5v0__filltie
XTAP_TAPCELL_ROW_3_123 VDD VSS gf180mcu_fd_sc_mcu7t5v0__filltie
XTAP_TAPCELL_ROW_3_124 VDD VSS gf180mcu_fd_sc_mcu7t5v0__filltie
XTAP_TAPCELL_ROW_3_125 VDD VSS gf180mcu_fd_sc_mcu7t5v0__filltie
XTAP_TAPCELL_ROW_40_306 VDD VSS gf180mcu_fd_sc_mcu7t5v0__filltie
XTAP_TAPCELL_ROW_40_307 VDD VSS gf180mcu_fd_sc_mcu7t5v0__filltie
XTAP_TAPCELL_ROW_40_308 VDD VSS gf180mcu_fd_sc_mcu7t5v0__filltie
XTAP_TAPCELL_ROW_40_309 VDD VSS gf180mcu_fd_sc_mcu7t5v0__filltie
XTAP_TAPCELL_ROW_40_310 VDD VSS gf180mcu_fd_sc_mcu7t5v0__filltie
XTAP_TAPCELL_ROW_41_311 VDD VSS gf180mcu_fd_sc_mcu7t5v0__filltie
XTAP_TAPCELL_ROW_41_312 VDD VSS gf180mcu_fd_sc_mcu7t5v0__filltie
XTAP_TAPCELL_ROW_41_313 VDD VSS gf180mcu_fd_sc_mcu7t5v0__filltie
XTAP_TAPCELL_ROW_41_314 VDD VSS gf180mcu_fd_sc_mcu7t5v0__filltie
XTAP_TAPCELL_ROW_41_315 VDD VSS gf180mcu_fd_sc_mcu7t5v0__filltie
XTAP_TAPCELL_ROW_42_316 VDD VSS gf180mcu_fd_sc_mcu7t5v0__filltie
XTAP_TAPCELL_ROW_42_317 VDD VSS gf180mcu_fd_sc_mcu7t5v0__filltie
XTAP_TAPCELL_ROW_42_318 VDD VSS gf180mcu_fd_sc_mcu7t5v0__filltie
XTAP_TAPCELL_ROW_42_319 VDD VSS gf180mcu_fd_sc_mcu7t5v0__filltie
XTAP_TAPCELL_ROW_42_320 VDD VSS gf180mcu_fd_sc_mcu7t5v0__filltie
XTAP_TAPCELL_ROW_43_321 VDD VSS gf180mcu_fd_sc_mcu7t5v0__filltie
XTAP_TAPCELL_ROW_43_322 VDD VSS gf180mcu_fd_sc_mcu7t5v0__filltie
XTAP_TAPCELL_ROW_43_323 VDD VSS gf180mcu_fd_sc_mcu7t5v0__filltie
XTAP_TAPCELL_ROW_43_324 VDD VSS gf180mcu_fd_sc_mcu7t5v0__filltie
XTAP_TAPCELL_ROW_43_325 VDD VSS gf180mcu_fd_sc_mcu7t5v0__filltie
XTAP_TAPCELL_ROW_44_326 VDD VSS gf180mcu_fd_sc_mcu7t5v0__filltie
XTAP_TAPCELL_ROW_44_327 VDD VSS gf180mcu_fd_sc_mcu7t5v0__filltie
XTAP_TAPCELL_ROW_44_328 VDD VSS gf180mcu_fd_sc_mcu7t5v0__filltie
XTAP_TAPCELL_ROW_44_329 VDD VSS gf180mcu_fd_sc_mcu7t5v0__filltie
XTAP_TAPCELL_ROW_44_330 VDD VSS gf180mcu_fd_sc_mcu7t5v0__filltie
XTAP_TAPCELL_ROW_45_331 VDD VSS gf180mcu_fd_sc_mcu7t5v0__filltie
XTAP_TAPCELL_ROW_45_332 VDD VSS gf180mcu_fd_sc_mcu7t5v0__filltie
XTAP_TAPCELL_ROW_45_333 VDD VSS gf180mcu_fd_sc_mcu7t5v0__filltie
XTAP_TAPCELL_ROW_45_334 VDD VSS gf180mcu_fd_sc_mcu7t5v0__filltie
XTAP_TAPCELL_ROW_45_335 VDD VSS gf180mcu_fd_sc_mcu7t5v0__filltie
XTAP_TAPCELL_ROW_46_336 VDD VSS gf180mcu_fd_sc_mcu7t5v0__filltie
XTAP_TAPCELL_ROW_46_337 VDD VSS gf180mcu_fd_sc_mcu7t5v0__filltie
XTAP_TAPCELL_ROW_46_338 VDD VSS gf180mcu_fd_sc_mcu7t5v0__filltie
XTAP_TAPCELL_ROW_46_339 VDD VSS gf180mcu_fd_sc_mcu7t5v0__filltie
XTAP_TAPCELL_ROW_46_340 VDD VSS gf180mcu_fd_sc_mcu7t5v0__filltie
XTAP_TAPCELL_ROW_47_341 VDD VSS gf180mcu_fd_sc_mcu7t5v0__filltie
XTAP_TAPCELL_ROW_47_342 VDD VSS gf180mcu_fd_sc_mcu7t5v0__filltie
XTAP_TAPCELL_ROW_47_343 VDD VSS gf180mcu_fd_sc_mcu7t5v0__filltie
XTAP_TAPCELL_ROW_47_344 VDD VSS gf180mcu_fd_sc_mcu7t5v0__filltie
XTAP_TAPCELL_ROW_47_345 VDD VSS gf180mcu_fd_sc_mcu7t5v0__filltie
XTAP_TAPCELL_ROW_48_346 VDD VSS gf180mcu_fd_sc_mcu7t5v0__filltie
XTAP_TAPCELL_ROW_48_347 VDD VSS gf180mcu_fd_sc_mcu7t5v0__filltie
XTAP_TAPCELL_ROW_48_348 VDD VSS gf180mcu_fd_sc_mcu7t5v0__filltie
XTAP_TAPCELL_ROW_48_349 VDD VSS gf180mcu_fd_sc_mcu7t5v0__filltie
XTAP_TAPCELL_ROW_48_350 VDD VSS gf180mcu_fd_sc_mcu7t5v0__filltie
XTAP_TAPCELL_ROW_49_351 VDD VSS gf180mcu_fd_sc_mcu7t5v0__filltie
XTAP_TAPCELL_ROW_49_352 VDD VSS gf180mcu_fd_sc_mcu7t5v0__filltie
XTAP_TAPCELL_ROW_49_353 VDD VSS gf180mcu_fd_sc_mcu7t5v0__filltie
XTAP_TAPCELL_ROW_49_354 VDD VSS gf180mcu_fd_sc_mcu7t5v0__filltie
XTAP_TAPCELL_ROW_49_355 VDD VSS gf180mcu_fd_sc_mcu7t5v0__filltie
XTAP_TAPCELL_ROW_49_356 VDD VSS gf180mcu_fd_sc_mcu7t5v0__filltie
XTAP_TAPCELL_ROW_49_357 VDD VSS gf180mcu_fd_sc_mcu7t5v0__filltie
XTAP_TAPCELL_ROW_49_358 VDD VSS gf180mcu_fd_sc_mcu7t5v0__filltie
XTAP_TAPCELL_ROW_49_359 VDD VSS gf180mcu_fd_sc_mcu7t5v0__filltie
XTAP_TAPCELL_ROW_49_360 VDD VSS gf180mcu_fd_sc_mcu7t5v0__filltie
XTAP_TAPCELL_ROW_49_361 VDD VSS gf180mcu_fd_sc_mcu7t5v0__filltie
XTAP_TAPCELL_ROW_4_126 VDD VSS gf180mcu_fd_sc_mcu7t5v0__filltie
XTAP_TAPCELL_ROW_4_127 VDD VSS gf180mcu_fd_sc_mcu7t5v0__filltie
XTAP_TAPCELL_ROW_4_128 VDD VSS gf180mcu_fd_sc_mcu7t5v0__filltie
XTAP_TAPCELL_ROW_4_129 VDD VSS gf180mcu_fd_sc_mcu7t5v0__filltie
XTAP_TAPCELL_ROW_4_130 VDD VSS gf180mcu_fd_sc_mcu7t5v0__filltie
XTAP_TAPCELL_ROW_5_131 VDD VSS gf180mcu_fd_sc_mcu7t5v0__filltie
XTAP_TAPCELL_ROW_5_132 VDD VSS gf180mcu_fd_sc_mcu7t5v0__filltie
XTAP_TAPCELL_ROW_5_133 VDD VSS gf180mcu_fd_sc_mcu7t5v0__filltie
XTAP_TAPCELL_ROW_5_134 VDD VSS gf180mcu_fd_sc_mcu7t5v0__filltie
XTAP_TAPCELL_ROW_5_135 VDD VSS gf180mcu_fd_sc_mcu7t5v0__filltie
XTAP_TAPCELL_ROW_6_136 VDD VSS gf180mcu_fd_sc_mcu7t5v0__filltie
XTAP_TAPCELL_ROW_6_137 VDD VSS gf180mcu_fd_sc_mcu7t5v0__filltie
XTAP_TAPCELL_ROW_6_138 VDD VSS gf180mcu_fd_sc_mcu7t5v0__filltie
XTAP_TAPCELL_ROW_6_139 VDD VSS gf180mcu_fd_sc_mcu7t5v0__filltie
XTAP_TAPCELL_ROW_6_140 VDD VSS gf180mcu_fd_sc_mcu7t5v0__filltie
XTAP_TAPCELL_ROW_7_141 VDD VSS gf180mcu_fd_sc_mcu7t5v0__filltie
XTAP_TAPCELL_ROW_7_142 VDD VSS gf180mcu_fd_sc_mcu7t5v0__filltie
XTAP_TAPCELL_ROW_7_143 VDD VSS gf180mcu_fd_sc_mcu7t5v0__filltie
XTAP_TAPCELL_ROW_7_144 VDD VSS gf180mcu_fd_sc_mcu7t5v0__filltie
XTAP_TAPCELL_ROW_7_145 VDD VSS gf180mcu_fd_sc_mcu7t5v0__filltie
XTAP_TAPCELL_ROW_8_146 VDD VSS gf180mcu_fd_sc_mcu7t5v0__filltie
XTAP_TAPCELL_ROW_8_147 VDD VSS gf180mcu_fd_sc_mcu7t5v0__filltie
XTAP_TAPCELL_ROW_8_148 VDD VSS gf180mcu_fd_sc_mcu7t5v0__filltie
XTAP_TAPCELL_ROW_8_149 VDD VSS gf180mcu_fd_sc_mcu7t5v0__filltie
XTAP_TAPCELL_ROW_8_150 VDD VSS gf180mcu_fd_sc_mcu7t5v0__filltie
XTAP_TAPCELL_ROW_9_151 VDD VSS gf180mcu_fd_sc_mcu7t5v0__filltie
XTAP_TAPCELL_ROW_9_152 VDD VSS gf180mcu_fd_sc_mcu7t5v0__filltie
XTAP_TAPCELL_ROW_9_153 VDD VSS gf180mcu_fd_sc_mcu7t5v0__filltie
XTAP_TAPCELL_ROW_9_154 VDD VSS gf180mcu_fd_sc_mcu7t5v0__filltie
XTAP_TAPCELL_ROW_9_155 VDD VSS gf180mcu_fd_sc_mcu7t5v0__filltie
Xn_1035 out_cas_int_b1 n_0478 VDD VDD VSS VSS gf180mcu_fd_sc_mcu7t5v0__clkinv_1
Xn_1036 out_cas_int_b0 n_0479 VDD VDD VSS VSS gf180mcu_fd_sc_mcu7t5v0__clkinv_1
Xn_1037 out_cas_int_b2 n_0480 VDD VDD VSS VSS gf180mcu_fd_sc_mcu7t5v0__clkinv_1
Xn_1038 out_cas_int_b3 n_0481 VDD VDD VSS VSS gf180mcu_fd_sc_mcu7t5v0__clkinv_1
Xn_1039 out_cas_int_b4 n_0482 VDD VDD VSS VSS gf180mcu_fd_sc_mcu7t5v0__clkinv_1
Xn_1040 out_cas_int_b5 n_0483 VDD VDD VSS VSS gf180mcu_fd_sc_mcu7t5v0__clkinv_1
Xn_1041 out_cas_int_b6 n_0484 VDD VDD VSS VSS gf180mcu_fd_sc_mcu7t5v0__clkinv_1
Xn_1042 out_cas_int_b7 n_0485 VDD VDD VSS VSS gf180mcu_fd_sc_mcu7t5v0__clkinv_1
Xn_1043 out_cas_int_b8 n_0486 VDD VDD VSS VSS gf180mcu_fd_sc_mcu7t5v0__clkinv_1
Xn_1044 out_cas_int_b9 n_0487 VDD VDD VSS VSS gf180mcu_fd_sc_mcu7t5v0__clkinv_1
Xn_1045 out_cas_int_b10 n_0488 VDD VDD VSS VSS gf180mcu_fd_sc_mcu7t5v0__clkinv_1
Xn_1046 out_cas_int_b11 n_0489 VDD VDD VSS VSS gf180mcu_fd_sc_mcu7t5v0__clkinv_1
Xn_1047 out_cas_int_b12 n_0490 VDD VDD VSS VSS gf180mcu_fd_sc_mcu7t5v0__clkinv_1
Xn_1048 out_cas_int_b13 n_0491 VDD VDD VSS VSS gf180mcu_fd_sc_mcu7t5v0__clkinv_1
Xn_1049 out_cas_int_b14 n_0492 VDD VDD VSS VSS gf180mcu_fd_sc_mcu7t5v0__clkinv_1
Xn_1050 out_cas_int_b15 n_0493 VDD VDD VSS VSS gf180mcu_fd_sc_mcu7t5v0__clkinv_1
Xn_1051 out_cas_int_b16 n_0494 VDD VDD VSS VSS gf180mcu_fd_sc_mcu7t5v0__clkinv_1
Xn_1052 out_cas_int_b22 n_0495 VDD VDD VSS VSS gf180mcu_fd_sc_mcu7t5v0__clkinv_1
Xn_1053 out_cas_int_b23 n_0496 VDD VDD VSS VSS gf180mcu_fd_sc_mcu7t5v0__clkinv_1
Xn_1054 u_cas_int_out_int1_b6 n_0497 VDD VDD VSS VSS gf180mcu_fd_sc_mcu7t5v0__clkinv_1
Xn_1055 u_cas_int_out_int1_b7 n_0498 VDD VDD VSS VSS gf180mcu_fd_sc_mcu7t5v0__clkinv_1
Xn_1056 u_cas_diff_u_diff3_in_min1_b13 n_0499 VDD VDD VSS VSS gf180mcu_fd_sc_mcu7t5v0__clkinv_1
Xn_1057 u_cas_diff_u_diff3_in_min1_b12 n_0500 VDD VDD VSS VSS gf180mcu_fd_sc_mcu7t5v0__clkinv_1
Xn_1058 u_cas_diff_u_diff3_in_min1_b11 n_0501 VDD VDD VSS VSS gf180mcu_fd_sc_mcu7t5v0__clkinv_1
Xn_1059 u_cas_diff_u_diff3_in_min1_b10 n_0502 VDD VDD VSS VSS gf180mcu_fd_sc_mcu7t5v0__clkinv_1
Xn_1060 u_cas_diff_u_diff3_in_min1_b9 n_0503 VDD VDD VSS VSS gf180mcu_fd_sc_mcu7t5v0__clkinv_1
Xn_1061 u_cas_diff_u_diff3_in_min1_b8 n_0504 VDD VDD VSS VSS gf180mcu_fd_sc_mcu7t5v0__clkinv_1
Xn_1062 u_cas_diff_out_diff2_b7 n_0505 VDD VDD VSS VSS gf180mcu_fd_sc_mcu7t5v0__clkinv_1
Xn_1063 u_cas_diff_u_diff3_in_min1_b7 n_0506 VDD VDD VSS VSS gf180mcu_fd_sc_mcu7t5v0__clkinv_1
Xn_1064 u_cas_diff_u_diff3_in_min1_b6 n_0507 VDD VDD VSS VSS gf180mcu_fd_sc_mcu7t5v0__clkinv_1
Xn_1065 u_cas_diff_out_diff2_b6 n_0508 VDD VDD VSS VSS gf180mcu_fd_sc_mcu7t5v0__clkinv_1
Xn_1066 u_cas_diff_u_diff3_in_min1_b5 n_0509 VDD VDD VSS VSS gf180mcu_fd_sc_mcu7t5v0__clkinv_1
Xn_1067 u_cas_diff_out_diff2_b5 n_0510 VDD VDD VSS VSS gf180mcu_fd_sc_mcu7t5v0__clkinv_1
Xn_1068 u_cas_diff_u_diff3_in_min1_b4 n_0511 VDD VDD VSS VSS gf180mcu_fd_sc_mcu7t5v0__clkinv_1
Xn_1069 u_cas_diff_u_diff3_in_min1_b3 n_0512 VDD VDD VSS VSS gf180mcu_fd_sc_mcu7t5v0__clkinv_1
Xn_1070 u_cas_diff_out_diff2_b3 n_0513 VDD VDD VSS VSS gf180mcu_fd_sc_mcu7t5v0__clkinv_1
Xn_1071 u_cas_diff_u_diff3_in_min1_b2 n_0514 VDD VDD VSS VSS gf180mcu_fd_sc_mcu7t5v0__clkinv_1
Xn_1072 u_cas_diff_u_diff3_in_min1_b1 n_0515 VDD VDD VSS VSS gf180mcu_fd_sc_mcu7t5v0__clkinv_1
Xn_1073 u_cas_diff_u_diff3_in_min1_b0 n_0516 VDD VDD VSS VSS gf180mcu_fd_sc_mcu7t5v0__clkinv_1
Xn_1074 u_cas_diff_out_diff2_b14 n_0517 VDD VDD VSS VSS gf180mcu_fd_sc_mcu7t5v0__clkinv_1
Xn_1075 u_cas_diff_out_diff2_b15 n_0518 VDD VDD VSS VSS gf180mcu_fd_sc_mcu7t5v0__clkinv_1
Xn_1076 u_cas_diff_out_diff2_b16 n_0519 VDD VDD VSS VSS gf180mcu_fd_sc_mcu7t5v0__clkinv_1
Xn_1077 u_cas_diff_out_diff2_b17 n_0520 VDD VDD VSS VSS gf180mcu_fd_sc_mcu7t5v0__clkinv_1
Xn_1078 u_cas_diff_out_diff2_b18 n_0521 VDD VDD VSS VSS gf180mcu_fd_sc_mcu7t5v0__clkinv_1
Xn_1079 u_cas_diff_out_diff2_b19 n_0522 VDD VDD VSS VSS gf180mcu_fd_sc_mcu7t5v0__clkinv_1
Xn_1080 u_cas_diff_out_diff2_b20 n_0523 VDD VDD VSS VSS gf180mcu_fd_sc_mcu7t5v0__clkinv_1
Xn_1081 u_cas_diff_u_diff3_in_min1_b21 n_0524 VDD VDD VSS VSS gf180mcu_fd_sc_mcu7t5v0__clkinv_1
Xn_1082 u_cas_diff_u_diff3_in_min1_b22 n_0525 VDD VDD VSS VSS gf180mcu_fd_sc_mcu7t5v0__clkinv_1
Xn_1083 u_cas_diff_out_diff2_b23 n_0526 VDD VDD VSS VSS gf180mcu_fd_sc_mcu7t5v0__clkinv_1
Xn_1084 u_cas_diff_out_diff1_b1 n_0527 VDD VDD VSS VSS gf180mcu_fd_sc_mcu7t5v0__clkinv_1
Xn_1085 u_cas_diff_out_diff1_b0 n_0528 VDD VDD VSS VSS gf180mcu_fd_sc_mcu7t5v0__clkinv_1
Xn_1086 u_cas_diff_u_diff2_in_min1_b2 n_0529 VDD VDD VSS VSS gf180mcu_fd_sc_mcu7t5v0__clkinv_1
Xn_1087 u_cas_diff_out_diff1_b2 n_0530 VDD VDD VSS VSS gf180mcu_fd_sc_mcu7t5v0__clkinv_1
Xn_1088 u_cas_diff_u_diff2_in_min1_b3 n_0531 VDD VDD VSS VSS gf180mcu_fd_sc_mcu7t5v0__clkinv_1
Xn_1089 u_cas_diff_out_diff1_b3 n_0532 VDD VDD VSS VSS gf180mcu_fd_sc_mcu7t5v0__clkinv_1
Xn_1090 u_cas_diff_u_diff2_in_min1_b4 n_0533 VDD VDD VSS VSS gf180mcu_fd_sc_mcu7t5v0__clkinv_1
Xn_1091 u_cas_diff_out_diff1_b4 n_0534 VDD VDD VSS VSS gf180mcu_fd_sc_mcu7t5v0__clkinv_1
Xn_1092 u_cas_diff_u_diff2_in_min1_b5 n_0535 VDD VDD VSS VSS gf180mcu_fd_sc_mcu7t5v0__clkinv_1
Xn_1093 u_cas_diff_out_diff1_b5 n_0536 VDD VDD VSS VSS gf180mcu_fd_sc_mcu7t5v0__clkinv_1
Xn_1094 u_cas_diff_u_diff2_in_min1_b6 n_0537 VDD VDD VSS VSS gf180mcu_fd_sc_mcu7t5v0__clkinv_1
Xn_1095 u_cas_diff_out_diff1_b6 n_0538 VDD VDD VSS VSS gf180mcu_fd_sc_mcu7t5v0__clkinv_1
Xn_1096 u_cas_diff_u_diff2_in_min1_b7 n_0539 VDD VDD VSS VSS gf180mcu_fd_sc_mcu7t5v0__clkinv_1
Xn_1097 u_cas_diff_out_diff1_b7 n_0540 VDD VDD VSS VSS gf180mcu_fd_sc_mcu7t5v0__clkinv_1
Xn_1098 u_cas_diff_u_diff2_in_min1_b8 n_0541 VDD VDD VSS VSS gf180mcu_fd_sc_mcu7t5v0__clkinv_1
Xn_1099 u_cas_diff_u_diff2_in_min1_b9 n_0542 VDD VDD VSS VSS gf180mcu_fd_sc_mcu7t5v0__clkinv_1
Xn_1100 u_cas_diff_out_diff1_b9 n_0543 VDD VDD VSS VSS gf180mcu_fd_sc_mcu7t5v0__clkinv_1
Xn_1101 u_cas_diff_u_diff2_in_min1_b10 n_0544 VDD VDD VSS VSS gf180mcu_fd_sc_mcu7t5v0__clkinv_1
Xn_1102 u_cas_diff_out_diff1_b10 n_0545 VDD VDD VSS VSS gf180mcu_fd_sc_mcu7t5v0__clkinv_1
Xn_1103 u_cas_diff_u_diff2_in_min1_b11 n_0546 VDD VDD VSS VSS gf180mcu_fd_sc_mcu7t5v0__clkinv_1
Xn_1104 u_cas_diff_out_diff1_b11 n_0547 VDD VDD VSS VSS gf180mcu_fd_sc_mcu7t5v0__clkinv_1
Xn_1105 u_cas_diff_u_diff2_in_min1_b12 n_0548 VDD VDD VSS VSS gf180mcu_fd_sc_mcu7t5v0__clkinv_1
Xn_1106 u_cas_diff_out_diff1_b12 n_0549 VDD VDD VSS VSS gf180mcu_fd_sc_mcu7t5v0__clkinv_1
Xn_1107 u_cas_diff_u_diff2_in_min1_b13 n_0550 VDD VDD VSS VSS gf180mcu_fd_sc_mcu7t5v0__clkinv_1
Xn_1108 u_cas_diff_out_diff1_b13 n_0551 VDD VDD VSS VSS gf180mcu_fd_sc_mcu7t5v0__clkinv_1
Xn_1109 u_cas_diff_u_diff2_in_min1_b14 n_0552 VDD VDD VSS VSS gf180mcu_fd_sc_mcu7t5v0__clkinv_1
Xn_1110 u_cas_diff_out_diff1_b14 n_0553 VDD VDD VSS VSS gf180mcu_fd_sc_mcu7t5v0__clkinv_1
Xn_1111 u_cas_diff_u_diff2_in_min1_b15 n_0554 VDD VDD VSS VSS gf180mcu_fd_sc_mcu7t5v0__clkinv_1
Xn_1112 u_cas_diff_out_diff1_b15 n_0555 VDD VDD VSS VSS gf180mcu_fd_sc_mcu7t5v0__clkinv_1
Xn_1113 u_cas_diff_out_diff1_b16 n_0556 VDD VDD VSS VSS gf180mcu_fd_sc_mcu7t5v0__clkinv_1
Xn_1114 u_cas_diff_u_diff2_in_min1_b17 n_0557 VDD VDD VSS VSS gf180mcu_fd_sc_mcu7t5v0__clkinv_1
Xn_1115 u_cas_diff_out_diff1_b17 n_0558 VDD VDD VSS VSS gf180mcu_fd_sc_mcu7t5v0__clkinv_1
Xn_1116 u_cas_diff_out_diff1_b18 n_0559 VDD VDD VSS VSS gf180mcu_fd_sc_mcu7t5v0__clkinv_1
Xn_1117 u_cas_diff_out_diff1_b19 n_0560 VDD VDD VSS VSS gf180mcu_fd_sc_mcu7t5v0__clkinv_1
Xn_1118 u_cas_diff_out_diff1_b20 n_0561 VDD VDD VSS VSS gf180mcu_fd_sc_mcu7t5v0__clkinv_1
Xn_1119 u_cas_diff_u_diff2_in_min1_b21 n_0562 VDD VDD VSS VSS gf180mcu_fd_sc_mcu7t5v0__clkinv_1
Xn_1120 u_cas_diff_u_diff2_in_min1_b22 n_0563 VDD VDD VSS VSS gf180mcu_fd_sc_mcu7t5v0__clkinv_1
Xn_1121 u_cas_diff_out_diff1_b22 n_0564 VDD VDD VSS VSS gf180mcu_fd_sc_mcu7t5v0__clkinv_1
Xn_1122 u_cas_diff_u_diff2_in_min1_b23 n_0565 VDD VDD VSS VSS gf180mcu_fd_sc_mcu7t5v0__clkinv_1
Xn_1123 u_cas_diff_out_diff1_b23 n_0566 VDD VDD VSS VSS gf180mcu_fd_sc_mcu7t5v0__clkinv_1
Xn_1124 u_cas_diff_u_diff1_in_min1_b2 n_0567 VDD VDD VSS VSS gf180mcu_fd_sc_mcu7t5v0__clkinv_1
Xn_1125 u_cas_diff_u_diff1_in_min1_b3 n_0568 VDD VDD VSS VSS gf180mcu_fd_sc_mcu7t5v0__clkinv_1
Xn_1126 u_cas_diff_u_diff1_in_min1_b4 n_0569 VDD VDD VSS VSS gf180mcu_fd_sc_mcu7t5v0__clkinv_1
Xn_1127 u_cas_diff_u_diff1_in_min1_b5 n_0570 VDD VDD VSS VSS gf180mcu_fd_sc_mcu7t5v0__clkinv_1
Xn_1128 u_cas_diff_u_diff1_in_min1_b6 n_0571 VDD VDD VSS VSS gf180mcu_fd_sc_mcu7t5v0__clkinv_1
Xn_1129 u_cas_diff_u_diff1_in_min1_b7 n_0572 VDD VDD VSS VSS gf180mcu_fd_sc_mcu7t5v0__clkinv_1
Xn_1130 u_cas_diff_u_diff1_in_min1_b10 n_0573 VDD VDD VSS VSS gf180mcu_fd_sc_mcu7t5v0__clkinv_1
Xn_1131 u_cas_diff_u_diff1_in_min1_b11 n_0574 VDD VDD VSS VSS gf180mcu_fd_sc_mcu7t5v0__clkinv_1
Xn_1132 u_cas_diff_u_diff1_in_min1_b12 n_0575 VDD VDD VSS VSS gf180mcu_fd_sc_mcu7t5v0__clkinv_1
Xn_1133 u_cas_diff_u_diff1_in_min1_b13 n_0576 VDD VDD VSS VSS gf180mcu_fd_sc_mcu7t5v0__clkinv_1
Xn_1134 u_cas_diff_u_diff1_in_min1_b14 n_0577 VDD VDD VSS VSS gf180mcu_fd_sc_mcu7t5v0__clkinv_1
Xn_1135 u_cas_diff_u_diff1_in_min1_b15 n_0578 VDD VDD VSS VSS gf180mcu_fd_sc_mcu7t5v0__clkinv_1
Xn_1136 u_cas_diff_u_diff1_in_min1_b17 n_0579 VDD VDD VSS VSS gf180mcu_fd_sc_mcu7t5v0__clkinv_1
Xn_1137 u_cas_diff_u_diff1_in_min1_b18 n_0580 VDD VDD VSS VSS gf180mcu_fd_sc_mcu7t5v0__clkinv_1
Xn_1138 u_cas_diff_u_diff1_in_min1_b19 n_0581 VDD VDD VSS VSS gf180mcu_fd_sc_mcu7t5v0__clkinv_1
Xn_1139 u_cas_diff_u_diff1_in_min1_b20 n_0582 VDD VDD VSS VSS gf180mcu_fd_sc_mcu7t5v0__clkinv_1
Xn_1140 u_cas_diff_u_diff1_in_min1_b21 n_0583 VDD VDD VSS VSS gf180mcu_fd_sc_mcu7t5v0__clkinv_1
Xn_1141 u_cas_diff_u_diff1_in_min1_b22 n_0584 VDD VDD VSS VSS gf180mcu_fd_sc_mcu7t5v0__clkinv_1
Xn_1142 u_cas_diff_u_diff1_in_min1_b23 n_0585 VDD VDD VSS VSS gf180mcu_fd_sc_mcu7t5v0__clkinv_1
Xn_1143 u_clock_div_counter_b0 n_0137 VDD VDD VSS VSS gf180mcu_fd_sc_mcu7t5v0__clkinv_1
Xn_1144 u_clock_div_counter_b0 u_clock_div_counter_b1 n_0586 VDD VDD VSS VSS
+ gf180mcu_fd_sc_mcu7t5v0__nand2_1
Xn_1145 u_clock_div_counter_b2 u_clock_div_counter_b0 u_clock_div_counter_b1 n_0587 VDD VDD VSS VSS
+ gf180mcu_fd_sc_mcu7t5v0__nand3_1
Xn_1146 u_clock_div_counter_b3 u_clock_div_counter_b2 u_clock_div_counter_b0 u_clock_div_counter_b1
+ n_0588 VDD VDD VSS VSS gf180mcu_fd_sc_mcu7t5v0__and4_1
Xn_1147 u_clock_div_counter_b4 n_0588 n_0589 VDD VDD VSS VSS gf180mcu_fd_sc_mcu7t5v0__nand2_1
Xn_1148 u_clock_div_counter_b4 n_0588 n_0141 VDD VDD VSS VSS gf180mcu_fd_sc_mcu7t5v0__xor2_1
Xn_1149 u_clock_div_counter_b4 u_clock_div_counter_b5 n_0588 n_0590 VDD VDD VSS VSS
+ gf180mcu_fd_sc_mcu7t5v0__nand3_1
Xn_1150 u_clock_div_counter_b5 n_0589 n_0142 VDD VDD VSS VSS gf180mcu_fd_sc_mcu7t5v0__xnor2_1
Xn_1151 u_clock_div_counter_b4 u_clock_div_counter_b5 u_clock_div_counter_b6 n_0588 n_0591 VDD VDD
+ VSS VSS gf180mcu_fd_sc_mcu7t5v0__nand4_1
Xn_1152 u_clock_div_counter_b6 n_0590 n_0143 VDD VDD VSS VSS gf180mcu_fd_sc_mcu7t5v0__xnor2_1
Xn_1153 u_clock_div_counter_b7 n_0591 n_0144 VDD VDD VSS VSS gf180mcu_fd_sc_mcu7t5v0__xnor2_1
Xn_1154 u_cas_int_out_int2_b0 out_cas_int_b0 n_0592 VDD VDD VSS VSS gf180mcu_fd_sc_mcu7t5v0__nand2_1
Xn_1155 u_cas_int_out_int2_b1 out_cas_int_b1 n_0593 VDD VDD VSS VSS gf180mcu_fd_sc_mcu7t5v0__nand2_1
Xn_1156 u_cas_int_out_int2_b1 out_cas_int_b1 n_0594 VDD VDD VSS VSS gf180mcu_fd_sc_mcu7t5v0__nor2_1
Xn_1157 u_cas_int_out_int2_b1 n_0478 n_0592 n_0123 VDD VDD VSS VSS gf180mcu_fd_sc_mcu7t5v0__xor3_1
Xn_1158 u_cas_int_out_int2_b2 out_cas_int_b2 n_0595 VDD VDD VSS VSS gf180mcu_fd_sc_mcu7t5v0__nor2_1
Xn_1159 u_cas_int_out_int2_b2 out_cas_int_b2 n_0596 VDD VDD VSS VSS gf180mcu_fd_sc_mcu7t5v0__and2_1
Xn_1160 n_0595 n_0596 n_0597 VDD VDD VSS VSS gf180mcu_fd_sc_mcu7t5v0__nor2_1
Xn_1161 u_cas_int_out_int2_b1 out_cas_int_b1 u_cas_int_out_int2_b0 out_cas_int_b0 n_0598 VDD VDD VSS
+ VSS gf180mcu_fd_sc_mcu7t5v0__oai211_1
Xn_1162 n_0594 n_0592 n_0593 n_0599 VDD VDD VSS VSS gf180mcu_fd_sc_mcu7t5v0__oai21_1
Xn_1163 n_0597 n_0599 n_0600 VDD VDD VSS VSS gf180mcu_fd_sc_mcu7t5v0__nor2_1
Xn_1164 n_0593 n_0598 n_0596 n_0595 n_0601 VDD VDD VSS VSS gf180mcu_fd_sc_mcu7t5v0__aoi211_1
Xn_1165 n_0597 n_0599 n_0602 VDD VDD VSS VSS gf180mcu_fd_sc_mcu7t5v0__nand2_1
Xn_1166 n_0600 n_0601 n_0129 VDD VDD VSS VSS gf180mcu_fd_sc_mcu7t5v0__nor2_1
Xn_1167 n_0597 n_0599 n_0596 n_0603 VDD VDD VSS VSS gf180mcu_fd_sc_mcu7t5v0__aoi21_1
Xn_1168 u_cas_int_out_int2_b3 out_cas_int_b3 n_0604 VDD VDD VSS VSS gf180mcu_fd_sc_mcu7t5v0__nor2_1
Xn_1169 u_cas_int_out_int2_b3 out_cas_int_b3 n_0605 VDD VDD VSS VSS gf180mcu_fd_sc_mcu7t5v0__or2_1
Xn_1170 u_cas_int_out_int2_b3 n_0481 n_0603 n_0130 VDD VDD VSS VSS gf180mcu_fd_sc_mcu7t5v0__xor3_1
Xn_1171 u_cas_int_out_int2_b2 out_cas_int_b2 u_cas_int_out_int2_b3 out_cas_int_b3 n_0606 VDD VDD VSS
+ VSS gf180mcu_fd_sc_mcu7t5v0__aoi22_1
Xn_1172 n_0606 n_0607 VDD VDD VSS VSS gf180mcu_fd_sc_mcu7t5v0__clkinv_1
Xn_1173 n_0601 n_0607 n_0605 n_0608 VDD VDD VSS VSS gf180mcu_fd_sc_mcu7t5v0__oai21_1
Xn_1174 n_0602 n_0606 n_0604 n_0609 VDD VDD VSS VSS gf180mcu_fd_sc_mcu7t5v0__aoi21_1
Xn_1175 u_cas_int_out_int2_b4 out_cas_int_b4 n_0610 VDD VDD VSS VSS gf180mcu_fd_sc_mcu7t5v0__nand2_1
Xn_1176 u_cas_int_out_int2_b4 out_cas_int_b4 n_0611 VDD VDD VSS VSS gf180mcu_fd_sc_mcu7t5v0__xor2_1
Xn_1177 n_0609 n_0611 n_0612 VDD VDD VSS VSS gf180mcu_fd_sc_mcu7t5v0__nand2_1
Xn_1178 n_0609 n_0611 n_0131 VDD VDD VSS VSS gf180mcu_fd_sc_mcu7t5v0__xor2_1
Xn_1179 n_0610 n_0612 n_0613 VDD VDD VSS VSS gf180mcu_fd_sc_mcu7t5v0__nand2_1
Xn_1180 u_cas_int_out_int2_b5 out_cas_int_b5 n_0614 VDD VDD VSS VSS gf180mcu_fd_sc_mcu7t5v0__nor2_1
Xn_1181 u_cas_int_out_int2_b5 out_cas_int_b5 n_0615 VDD VDD VSS VSS gf180mcu_fd_sc_mcu7t5v0__xor2_1
Xn_1182 n_0613 n_0615 n_0132 VDD VDD VSS VSS gf180mcu_fd_sc_mcu7t5v0__xor2_1
Xn_1183 u_cas_int_out_int2_b4 out_cas_int_b4 u_cas_int_out_int2_b5 out_cas_int_b5 n_0616 VDD VDD VSS
+ VSS gf180mcu_fd_sc_mcu7t5v0__aoi22_1
Xn_1184 n_0612 n_0616 n_0614 n_0617 VDD VDD VSS VSS gf180mcu_fd_sc_mcu7t5v0__aoi21_1
Xn_1185 u_cas_int_out_int2_b6 out_cas_int_b6 n_0618 VDD VDD VSS VSS gf180mcu_fd_sc_mcu7t5v0__or2_1
Xn_1186 u_cas_int_out_int2_b6 out_cas_int_b6 n_0619 VDD VDD VSS VSS gf180mcu_fd_sc_mcu7t5v0__nand2_1
Xn_1187 n_0618 n_0619 n_0620 VDD VDD VSS VSS gf180mcu_fd_sc_mcu7t5v0__and2_1
Xn_1188 n_0617 n_0618 n_0619 n_0621 VDD VDD VSS VSS gf180mcu_fd_sc_mcu7t5v0__nand3_1
Xn_1189 n_0617 n_0620 n_0133 VDD VDD VSS VSS gf180mcu_fd_sc_mcu7t5v0__xor2_1
Xn_1190 u_cas_int_out_int2_b7 out_cas_int_b7 n_0622 VDD VDD VSS VSS gf180mcu_fd_sc_mcu7t5v0__or2_1
Xn_1191 u_cas_int_out_int2_b7 out_cas_int_b7 n_0623 VDD VDD VSS VSS gf180mcu_fd_sc_mcu7t5v0__nand2_1
Xn_1192 u_cas_int_out_int2_b7 out_cas_int_b7 n_0624 VDD VDD VSS VSS gf180mcu_fd_sc_mcu7t5v0__xor2_1
Xn_1193 n_0619 n_0621 n_0622 n_0623 n_0625 VDD VDD VSS VSS gf180mcu_fd_sc_mcu7t5v0__and4_1
Xn_1194 n_0619 n_0621 n_0622 n_0623 n_0626 VDD VDD VSS VSS gf180mcu_fd_sc_mcu7t5v0__aoi22_1
Xn_1195 n_0625 n_0626 n_0134 VDD VDD VSS VSS gf180mcu_fd_sc_mcu7t5v0__or2_1
Xn_1196 n_0618 n_0619 n_0622 n_0623 n_0627 VDD VDD VSS VSS gf180mcu_fd_sc_mcu7t5v0__nand4_1
Xn_1197 n_0611 n_0615 n_0620 n_0624 n_0628 VDD VDD VSS VSS gf180mcu_fd_sc_mcu7t5v0__and4_1
Xn_1198 n_0611 n_0615 n_0620 n_0624 n_0629 VDD VDD VSS VSS gf180mcu_fd_sc_mcu7t5v0__nand4_1
Xn_1199 n_0614 n_0616 n_0630 VDD VDD VSS VSS gf180mcu_fd_sc_mcu7t5v0__or2_1
Xn_1200 n_0627 n_0630 n_0631 VDD VDD VSS VSS gf180mcu_fd_sc_mcu7t5v0__or2_1
Xn_1201 n_0619 n_0623 n_0632 VDD VDD VSS VSS gf180mcu_fd_sc_mcu7t5v0__nand2_1
Xn_1202 n_0622 n_0632 n_0633 VDD VDD VSS VSS gf180mcu_fd_sc_mcu7t5v0__nand2_1
Xn_1203 n_0627 n_0630 n_0633 n_0634 VDD VDD VSS VSS gf180mcu_fd_sc_mcu7t5v0__oai21_1
Xn_1204 n_0609 n_0628 n_0634 n_0635 VDD VDD VSS VSS gf180mcu_fd_sc_mcu7t5v0__aoi21_1
Xn_1205 n_0608 n_0629 n_0631 n_0633 n_0636 VDD VDD VSS VSS gf180mcu_fd_sc_mcu7t5v0__oai211_1
Xn_1206 u_cas_int_out_int2_b8 out_cas_int_b8 n_0637 VDD VDD VSS VSS gf180mcu_fd_sc_mcu7t5v0__and2_1
Xn_1207 u_cas_int_out_int2_b8 out_cas_int_b8 n_0638 VDD VDD VSS VSS gf180mcu_fd_sc_mcu7t5v0__nor2_1
Xn_1208 n_0637 n_0638 n_0639 VDD VDD VSS VSS gf180mcu_fd_sc_mcu7t5v0__nor2_1
Xn_1209 n_0636 n_0639 n_0135 VDD VDD VSS VSS gf180mcu_fd_sc_mcu7t5v0__xor2_1
Xn_1210 n_0636 n_0639 n_0637 n_0640 VDD VDD VSS VSS gf180mcu_fd_sc_mcu7t5v0__aoi21_1
Xn_1211 u_cas_int_out_int2_b9 out_cas_int_b9 n_0641 VDD VDD VSS VSS gf180mcu_fd_sc_mcu7t5v0__or2_1
Xn_1212 u_cas_int_out_int2_b9 out_cas_int_b9 n_0642 VDD VDD VSS VSS gf180mcu_fd_sc_mcu7t5v0__nand2_1
Xn_1213 u_cas_int_out_int2_b9 n_0487 n_0640 n_0136 VDD VDD VSS VSS gf180mcu_fd_sc_mcu7t5v0__xor3_1
Xn_1214 n_0639 n_0641 n_0642 n_0643 VDD VDD VSS VSS gf180mcu_fd_sc_mcu7t5v0__and3_1
Xn_1215 u_cas_int_out_int2_b9 out_cas_int_b9 u_cas_int_out_int2_b8 out_cas_int_b8 n_0644 VDD VDD VSS
+ VSS gf180mcu_fd_sc_mcu7t5v0__oai211_1
Xn_1216 n_0642 n_0644 n_0645 VDD VDD VSS VSS gf180mcu_fd_sc_mcu7t5v0__nand2_1
Xn_1217 n_0645 n_0646 VDD VDD VSS VSS gf180mcu_fd_sc_mcu7t5v0__clkinv_1
Xn_1218 n_0636 n_0643 n_0645 n_0647 VDD VDD VSS VSS gf180mcu_fd_sc_mcu7t5v0__aoi21_1
Xn_1219 u_cas_int_out_int2_b10 out_cas_int_b10 n_0648 VDD VDD VSS VSS gf180mcu_fd_sc_mcu7t5v0__or2_1
Xn_1220 u_cas_int_out_int2_b10 out_cas_int_b10 n_0649 VDD VDD VSS VSS
+ gf180mcu_fd_sc_mcu7t5v0__and2_1
Xn_1221 u_cas_int_out_int2_b10 out_cas_int_b10 n_0650 VDD VDD VSS VSS
+ gf180mcu_fd_sc_mcu7t5v0__nand2_1
Xn_1222 n_0647 n_0650 n_0651 VDD VDD VSS VSS gf180mcu_fd_sc_mcu7t5v0__nand2_1
Xn_1223 u_cas_int_out_int2_b10 n_0488 n_0647 n_0113 VDD VDD VSS VSS gf180mcu_fd_sc_mcu7t5v0__xor3_1
Xn_1224 u_cas_int_out_int2_b11 out_cas_int_b11 n_0652 VDD VDD VSS VSS gf180mcu_fd_sc_mcu7t5v0__or2_1
Xn_1225 u_cas_int_out_int2_b11 out_cas_int_b11 n_0653 VDD VDD VSS VSS
+ gf180mcu_fd_sc_mcu7t5v0__and2_1
Xn_1226 u_cas_int_out_int2_b11 out_cas_int_b11 n_0654 VDD VDD VSS VSS
+ gf180mcu_fd_sc_mcu7t5v0__nand2_1
Xn_1227 n_0648 n_0651 n_0655 VDD VDD VSS VSS gf180mcu_fd_sc_mcu7t5v0__nand2_1
Xn_1228 u_cas_int_out_int2_b11 n_0489 n_0655 n_0114 VDD VDD VSS VSS gf180mcu_fd_sc_mcu7t5v0__xor3_1
Xn_1229 n_0650 n_0654 n_0656 VDD VDD VSS VSS gf180mcu_fd_sc_mcu7t5v0__nand2_1
Xn_1230 n_0652 n_0656 n_0657 VDD VDD VSS VSS gf180mcu_fd_sc_mcu7t5v0__nand2_1
Xn_1231 u_cas_int_out_int2_b10 out_cas_int_b10 u_cas_int_out_int2_b11 out_cas_int_b11 n_0658 VDD VDD
+ VSS VSS gf180mcu_fd_sc_mcu7t5v0__oai22_1
Xn_1232 n_0658 n_0653 n_0649 n_0659 VDD VDD VSS VSS gf180mcu_fd_sc_mcu7t5v0__nor3_1
Xn_1233 n_0648 n_0650 n_0652 n_0654 n_0660 VDD VDD VSS VSS gf180mcu_fd_sc_mcu7t5v0__nand4_1
Xn_1234 n_0647 n_0660 n_0657 n_0661 VDD VDD VSS VSS gf180mcu_fd_sc_mcu7t5v0__oai21_1
Xn_1235 u_cas_int_out_int2_b12 out_cas_int_b12 n_0662 VDD VDD VSS VSS gf180mcu_fd_sc_mcu7t5v0__or2_1
Xn_1236 u_cas_int_out_int2_b12 out_cas_int_b12 n_0663 VDD VDD VSS VSS
+ gf180mcu_fd_sc_mcu7t5v0__nand2_1
Xn_1237 u_cas_int_out_int2_b12 out_cas_int_b12 n_0661 n_0115 VDD VDD VSS VSS
+ gf180mcu_fd_sc_mcu7t5v0__xor3_1
Xn_1238 u_cas_int_out_int2_b13 out_cas_int_b13 n_0664 VDD VDD VSS VSS gf180mcu_fd_sc_mcu7t5v0__or2_1
Xn_1239 u_cas_int_out_int2_b13 out_cas_int_b13 n_0665 VDD VDD VSS VSS
+ gf180mcu_fd_sc_mcu7t5v0__nand2_1
Xn_1240 n_0647 n_0660 n_0663 n_0657 n_0666 VDD VDD VSS VSS gf180mcu_fd_sc_mcu7t5v0__oai211_1
Xn_1241 n_0662 n_0666 n_0667 VDD VDD VSS VSS gf180mcu_fd_sc_mcu7t5v0__nand2_1
Xn_1242 u_cas_int_out_int2_b13 n_0491 n_0667 n_0116 VDD VDD VSS VSS gf180mcu_fd_sc_mcu7t5v0__xor3_1
Xn_1243 n_0662 n_0663 n_0664 n_0665 n_0668 VDD VDD VSS VSS gf180mcu_fd_sc_mcu7t5v0__and4_1
Xn_1244 n_0663 n_0665 n_0669 VDD VDD VSS VSS gf180mcu_fd_sc_mcu7t5v0__nand2_1
Xn_1245 n_0664 n_0669 n_0670 VDD VDD VSS VSS gf180mcu_fd_sc_mcu7t5v0__and2_1
Xn_1246 n_0664 n_0669 n_0671 VDD VDD VSS VSS gf180mcu_fd_sc_mcu7t5v0__nand2_1
Xn_1247 n_0661 n_0668 n_0670 n_0672 VDD VDD VSS VSS gf180mcu_fd_sc_mcu7t5v0__aoi21_1
Xn_1248 u_cas_int_out_int2_b14 out_cas_int_b14 n_0673 VDD VDD VSS VSS gf180mcu_fd_sc_mcu7t5v0__or2_1
Xn_1249 u_cas_int_out_int2_b14 out_cas_int_b14 n_0674 VDD VDD VSS VSS
+ gf180mcu_fd_sc_mcu7t5v0__nand2_1
Xn_1250 n_0673 n_0674 n_0675 VDD VDD VSS VSS gf180mcu_fd_sc_mcu7t5v0__nand2_1
Xn_1251 n_0672 n_0675 n_0117 VDD VDD VSS VSS gf180mcu_fd_sc_mcu7t5v0__xor2_1
Xn_1252 u_cas_int_out_int2_b15 out_cas_int_b15 n_0676 VDD VDD VSS VSS
+ gf180mcu_fd_sc_mcu7t5v0__nor2_1
Xn_1253 u_cas_int_out_int2_b15 out_cas_int_b15 n_0677 VDD VDD VSS VSS gf180mcu_fd_sc_mcu7t5v0__or2_1
Xn_1254 u_cas_int_out_int2_b15 out_cas_int_b15 n_0678 VDD VDD VSS VSS
+ gf180mcu_fd_sc_mcu7t5v0__nand2_1
Xn_1255 n_0677 n_0678 n_0679 VDD VDD VSS VSS gf180mcu_fd_sc_mcu7t5v0__nand2_1
Xn_1256 n_0672 n_0675 n_0674 n_0680 VDD VDD VSS VSS gf180mcu_fd_sc_mcu7t5v0__oai21_1
Xn_1257 n_0679 n_0680 n_0681 VDD VDD VSS VSS gf180mcu_fd_sc_mcu7t5v0__nand2_1
Xn_1258 u_cas_int_out_int2_b14 out_cas_int_b14 n_0679 n_0682 VDD VDD VSS VSS
+ gf180mcu_fd_sc_mcu7t5v0__aoi21_1
Xn_1259 n_0672 n_0675 n_0682 n_0683 VDD VDD VSS VSS gf180mcu_fd_sc_mcu7t5v0__oai21_1
Xn_1260 n_0681 n_0683 n_0118 VDD VDD VSS VSS gf180mcu_fd_sc_mcu7t5v0__nand2_1
Xn_1261 u_cas_int_out_int2_b16 out_cas_int_b16 n_0684 VDD VDD VSS VSS
+ gf180mcu_fd_sc_mcu7t5v0__nand2_1
Xn_1262 u_cas_int_out_int2_b16 out_cas_int_b16 n_0685 VDD VDD VSS VSS
+ gf180mcu_fd_sc_mcu7t5v0__xor2_1
Xn_1263 u_cas_int_out_int2_b14 out_cas_int_b14 u_cas_int_out_int2_b15 out_cas_int_b15 n_0686 VDD VDD
+ VSS VSS gf180mcu_fd_sc_mcu7t5v0__aoi22_1
Xn_1264 n_0674 n_0678 n_0676 n_0687 VDD VDD VSS VSS gf180mcu_fd_sc_mcu7t5v0__aoi21_1
Xn_1265 n_0673 n_0674 n_0677 n_0678 n_0688 VDD VDD VSS VSS gf180mcu_fd_sc_mcu7t5v0__and4_1
Xn_1266 n_0673 n_0674 n_0677 n_0678 n_0689 VDD VDD VSS VSS gf180mcu_fd_sc_mcu7t5v0__nand4_1
Xn_1267 n_0645 n_0659 n_0656 n_0652 n_0690 VDD VDD VSS VSS gf180mcu_fd_sc_mcu7t5v0__aoi22_1
Xn_1268 n_0646 n_0660 n_0657 n_0691 VDD VDD VSS VSS gf180mcu_fd_sc_mcu7t5v0__oai21_1
Xn_1269 n_0668 n_0688 n_0692 VDD VDD VSS VSS gf180mcu_fd_sc_mcu7t5v0__and2_1
Xn_1270 n_0668 n_0688 n_0693 VDD VDD VSS VSS gf180mcu_fd_sc_mcu7t5v0__nand2_1
Xn_1271 n_0670 n_0688 n_0687 n_0694 VDD VDD VSS VSS gf180mcu_fd_sc_mcu7t5v0__aoi21_1
Xn_1272 n_0671 n_0689 n_0686 n_0676 n_0695 VDD VDD VSS VSS gf180mcu_fd_sc_mcu7t5v0__oai22_1
Xn_1273 n_0691 n_0692 n_0695 n_0696 VDD VDD VSS VSS gf180mcu_fd_sc_mcu7t5v0__aoi21_1
Xn_1274 n_0690 n_0693 n_0694 n_0697 VDD VDD VSS VSS gf180mcu_fd_sc_mcu7t5v0__oai21_1
Xn_1275 n_0643 n_0659 n_0668 n_0688 n_0698 VDD VDD VSS VSS gf180mcu_fd_sc_mcu7t5v0__and4_1
Xn_1276 n_0643 n_0659 n_0668 n_0688 n_0699 VDD VDD VSS VSS gf180mcu_fd_sc_mcu7t5v0__nand4_1
Xn_1277 n_0636 n_0698 n_0697 n_0700 VDD VDD VSS VSS gf180mcu_fd_sc_mcu7t5v0__aoi21_1
Xn_1278 n_0635 n_0699 n_0696 n_0701 VDD VDD VSS VSS gf180mcu_fd_sc_mcu7t5v0__oai21_1
Xn_1279 n_0701 n_0685 n_0702 VDD VDD VSS VSS gf180mcu_fd_sc_mcu7t5v0__nand2_1
Xn_1280 n_0685 n_0701 n_0119 VDD VDD VSS VSS gf180mcu_fd_sc_mcu7t5v0__xor2_1
Xn_1281 n_0684 n_0702 n_0703 VDD VDD VSS VSS gf180mcu_fd_sc_mcu7t5v0__nand2_1
Xn_1282 u_cas_int_out_int2_b17 out_cas_int_b17 n_0704 VDD VDD VSS VSS
+ gf180mcu_fd_sc_mcu7t5v0__nor2_1
Xn_1283 u_cas_int_out_int2_b17 out_cas_int_b17 n_0705 VDD VDD VSS VSS
+ gf180mcu_fd_sc_mcu7t5v0__nand2_1
Xn_1284 u_cas_int_out_int2_b17 out_cas_int_b17 n_0706 VDD VDD VSS VSS
+ gf180mcu_fd_sc_mcu7t5v0__xor2_1
Xn_1285 n_0703 n_0706 n_0120 VDD VDD VSS VSS gf180mcu_fd_sc_mcu7t5v0__xor2_1
Xn_1286 u_cas_int_out_int2_b18 out_cas_int_b18 n_0707 VDD VDD VSS VSS gf180mcu_fd_sc_mcu7t5v0__or2_1
Xn_1287 u_cas_int_out_int2_b18 out_cas_int_b18 n_0708 VDD VDD VSS VSS
+ gf180mcu_fd_sc_mcu7t5v0__nand2_1
Xn_1288 n_0707 n_0708 n_0709 VDD VDD VSS VSS gf180mcu_fd_sc_mcu7t5v0__nand2_1
Xn_1289 n_0684 n_0705 n_0704 n_0710 VDD VDD VSS VSS gf180mcu_fd_sc_mcu7t5v0__aoi21_1
Xn_1290 n_0685 n_0706 n_0711 VDD VDD VSS VSS gf180mcu_fd_sc_mcu7t5v0__and2_1
Xn_1291 n_0701 n_0711 n_0710 n_0712 VDD VDD VSS VSS gf180mcu_fd_sc_mcu7t5v0__aoi21_1
Xn_1292 n_0709 n_0712 n_0121 VDD VDD VSS VSS gf180mcu_fd_sc_mcu7t5v0__xor2_1
Xn_1293 u_cas_int_out_int2_b19 out_cas_int_b19 n_0713 VDD VDD VSS VSS gf180mcu_fd_sc_mcu7t5v0__or2_1
Xn_1294 u_cas_int_out_int2_b19 out_cas_int_b19 n_0714 VDD VDD VSS VSS
+ gf180mcu_fd_sc_mcu7t5v0__nand2_1
Xn_1295 n_0709 n_0712 n_0708 n_0715 VDD VDD VSS VSS gf180mcu_fd_sc_mcu7t5v0__oai21_1
Xn_1296 u_cas_int_out_int2_b19 out_cas_int_b19 n_0715 n_0122 VDD VDD VSS VSS
+ gf180mcu_fd_sc_mcu7t5v0__xor3_1
Xn_1297 n_0707 n_0708 n_0713 n_0714 n_0716 VDD VDD VSS VSS gf180mcu_fd_sc_mcu7t5v0__and4_1
Xn_1298 n_0685 n_0706 n_0716 n_0717 VDD VDD VSS VSS gf180mcu_fd_sc_mcu7t5v0__and3_1
Xn_1299 n_0685 n_0706 n_0716 n_0718 VDD VDD VSS VSS gf180mcu_fd_sc_mcu7t5v0__nand3_1
Xn_1300 n_0710 n_0716 n_0719 VDD VDD VSS VSS gf180mcu_fd_sc_mcu7t5v0__nand2_1
Xn_1301 n_0713 out_cas_int_b18 u_cas_int_out_int2_b18 n_0720 VDD VDD VSS VSS
+ gf180mcu_fd_sc_mcu7t5v0__nand3_1
Xn_1302 n_0714 n_0719 n_0720 n_0721 VDD VDD VSS VSS gf180mcu_fd_sc_mcu7t5v0__and3_1
Xn_1303 n_0714 n_0719 n_0720 n_0722 VDD VDD VSS VSS gf180mcu_fd_sc_mcu7t5v0__nand3_1
Xn_1304 n_0701 n_0717 n_0722 n_0723 VDD VDD VSS VSS gf180mcu_fd_sc_mcu7t5v0__aoi21_1
Xn_1305 n_0700 n_0718 n_0721 n_0724 VDD VDD VSS VSS gf180mcu_fd_sc_mcu7t5v0__oai21_1
Xn_1306 u_cas_int_out_int2_b20 out_cas_int_b20 n_0725 VDD VDD VSS VSS
+ gf180mcu_fd_sc_mcu7t5v0__nor2_1
Xn_1307 u_cas_int_out_int2_b20 out_cas_int_b20 n_0726 VDD VDD VSS VSS
+ gf180mcu_fd_sc_mcu7t5v0__and2_1
Xn_1308 n_0725 n_0726 n_0727 VDD VDD VSS VSS gf180mcu_fd_sc_mcu7t5v0__nor2_1
Xn_1309 n_0724 n_0727 n_0124 VDD VDD VSS VSS gf180mcu_fd_sc_mcu7t5v0__xor2_1
Xn_1310 n_0724 n_0727 n_0726 n_0728 VDD VDD VSS VSS gf180mcu_fd_sc_mcu7t5v0__aoi21_1
Xn_1311 u_cas_int_out_int2_b21 out_cas_int_b21 n_0729 VDD VDD VSS VSS gf180mcu_fd_sc_mcu7t5v0__or2_1
Xn_1312 u_cas_int_out_int2_b21 out_cas_int_b21 n_0730 VDD VDD VSS VSS
+ gf180mcu_fd_sc_mcu7t5v0__nand2_1
Xn_1313 u_cas_int_out_int2_b21 out_cas_int_b21 n_0728 n_0125 VDD VDD VSS VSS
+ gf180mcu_fd_sc_mcu7t5v0__xnor3_1
Xn_1314 n_0727 n_0729 n_0730 n_0731 VDD VDD VSS VSS gf180mcu_fd_sc_mcu7t5v0__nand3_1
Xn_1315 n_0731 n_0732 VDD VDD VSS VSS gf180mcu_fd_sc_mcu7t5v0__clkinv_1
Xn_1316 n_0729 out_cas_int_b20 u_cas_int_out_int2_b20 n_0733 VDD VDD VSS VSS
+ gf180mcu_fd_sc_mcu7t5v0__nand3_1
Xn_1317 n_0730 n_0733 n_0734 VDD VDD VSS VSS gf180mcu_fd_sc_mcu7t5v0__and2_1
Xn_1318 n_0730 n_0733 n_0735 VDD VDD VSS VSS gf180mcu_fd_sc_mcu7t5v0__nand2_1
Xn_1319 n_0724 n_0732 n_0735 n_0736 VDD VDD VSS VSS gf180mcu_fd_sc_mcu7t5v0__aoi21_1
Xn_1320 n_0723 n_0731 n_0734 n_0737 VDD VDD VSS VSS gf180mcu_fd_sc_mcu7t5v0__oai21_1
Xn_1321 u_cas_int_out_int2_b22 out_cas_int_b22 n_0738 VDD VDD VSS VSS
+ gf180mcu_fd_sc_mcu7t5v0__nor2_1
Xn_1322 u_cas_int_out_int2_b22 out_cas_int_b22 n_0739 VDD VDD VSS VSS
+ gf180mcu_fd_sc_mcu7t5v0__and2_1
Xn_1323 u_cas_int_out_int2_b22 out_cas_int_b22 n_0740 VDD VDD VSS VSS
+ gf180mcu_fd_sc_mcu7t5v0__nand2_1
Xn_1324 u_cas_int_out_int2_b22 out_cas_int_b22 n_0737 n_0126 VDD VDD VSS VSS
+ gf180mcu_fd_sc_mcu7t5v0__xor3_1
Xn_1325 u_cas_int_out_int2_b23 out_cas_int_b23 n_0741 VDD VDD VSS VSS
+ gf180mcu_fd_sc_mcu7t5v0__nand2_1
Xn_1326 u_cas_int_out_int2_b23 n_0496 n_0742 VDD VDD VSS VSS gf180mcu_fd_sc_mcu7t5v0__xor2_1
Xn_1327 n_0736 n_0738 n_0740 n_0743 VDD VDD VSS VSS gf180mcu_fd_sc_mcu7t5v0__oai21_1
Xn_1328 n_0742 n_0743 n_0744 VDD VDD VSS VSS gf180mcu_fd_sc_mcu7t5v0__nand2_1
Xn_1329 u_cas_int_out_int2_b22 out_cas_int_b22 n_0742 n_0745 VDD VDD VSS VSS
+ gf180mcu_fd_sc_mcu7t5v0__aoi21_1
Xn_1330 n_0736 n_0738 n_0739 n_0745 n_0746 VDD VDD VSS VSS gf180mcu_fd_sc_mcu7t5v0__oai31_1
Xn_1331 n_0744 n_0746 n_0127 VDD VDD VSS VSS gf180mcu_fd_sc_mcu7t5v0__nand2_1
Xn_1332 n_0742 n_0739 n_0738 n_0747 VDD VDD VSS VSS gf180mcu_fd_sc_mcu7t5v0__nor3_1
Xn_1333 n_0747 n_0748 VDD VDD VSS VSS gf180mcu_fd_sc_mcu7t5v0__clkinv_1
Xn_1334 n_0737 n_0747 n_0749 VDD VDD VSS VSS gf180mcu_fd_sc_mcu7t5v0__nand2_1
Xn_1335 u_cas_int_out_int2_b23 out_cas_int_b23 u_cas_int_out_int2_b22 out_cas_int_b22 n_0750 VDD VDD
+ VSS VSS gf180mcu_fd_sc_mcu7t5v0__oai211_1
Xn_1336 n_0741 n_0750 n_0751 VDD VDD VSS VSS gf180mcu_fd_sc_mcu7t5v0__and2_1
Xn_1337 u_cas_int_out_int2_b24 out_cas_int_b24 n_0752 VDD VDD VSS VSS
+ gf180mcu_fd_sc_mcu7t5v0__xnor2_1
Xn_1338 n_0749 n_0751 n_0752 n_0753 VDD VDD VSS VSS gf180mcu_fd_sc_mcu7t5v0__aoi21_1
Xn_1339 n_0741 n_0750 n_0752 n_0754 VDD VDD VSS VSS gf180mcu_fd_sc_mcu7t5v0__and3_1
Xn_1340 n_0736 n_0748 n_0754 n_0755 VDD VDD VSS VSS gf180mcu_fd_sc_mcu7t5v0__oai21_1
Xn_1341 n_0755 n_0756 VDD VDD VSS VSS gf180mcu_fd_sc_mcu7t5v0__clkinv_1
Xn_1342 n_0753 n_0756 n_0128 VDD VDD VSS VSS gf180mcu_fd_sc_mcu7t5v0__nor2_1
Xn_1343 u_cas_int_out_int2_b1 u_cas_int_out_int1_b1 n_0757 VDD VDD VSS VSS
+ gf180mcu_fd_sc_mcu7t5v0__nand2_1
Xn_1344 u_cas_int_out_int2_b0 u_cas_int_out_int1_b0 n_0758 VDD VDD VSS VSS
+ gf180mcu_fd_sc_mcu7t5v0__nand2_1
Xn_1345 u_cas_int_out_int2_b1 u_cas_int_out_int1_b1 n_0758 n_0098 VDD VDD VSS VSS
+ gf180mcu_fd_sc_mcu7t5v0__xnor3_1
Xn_1346 u_cas_int_out_int2_b2 u_cas_int_out_int1_b2 n_0759 VDD VDD VSS VSS
+ gf180mcu_fd_sc_mcu7t5v0__and2_1
Xn_1347 u_cas_int_out_int2_b2 u_cas_int_out_int1_b2 n_0760 VDD VDD VSS VSS
+ gf180mcu_fd_sc_mcu7t5v0__nor2_1
Xn_1348 u_cas_int_out_int2_b1 u_cas_int_out_int1_b1 u_cas_int_out_int1_b0 u_cas_int_out_int2_b0
+ n_0761 VDD VDD VSS VSS gf180mcu_fd_sc_mcu7t5v0__oai211_1
Xn_1349 n_0757 n_0761 n_0762 VDD VDD VSS VSS gf180mcu_fd_sc_mcu7t5v0__nand2_1
Xn_1350 n_0757 n_0761 n_0760 n_0759 n_0763 VDD VDD VSS VSS gf180mcu_fd_sc_mcu7t5v0__aoi211_1
Xn_1351 u_cas_int_out_int2_b2 u_cas_int_out_int1_b2 n_0762 n_0104 VDD VDD VSS VSS
+ gf180mcu_fd_sc_mcu7t5v0__xor3_1
Xn_1352 u_cas_int_out_int2_b2 u_cas_int_out_int1_b2 n_0763 n_0764 VDD VDD VSS VSS
+ gf180mcu_fd_sc_mcu7t5v0__aoi21_1
Xn_1353 u_cas_int_out_int2_b3 u_cas_int_out_int1_b3 n_0765 VDD VDD VSS VSS
+ gf180mcu_fd_sc_mcu7t5v0__nand2_1
Xn_1354 u_cas_int_out_int2_b3 u_cas_int_out_int1_b3 n_0766 VDD VDD VSS VSS
+ gf180mcu_fd_sc_mcu7t5v0__nor2_1
Xn_1355 u_cas_int_out_int2_b3 u_cas_int_out_int1_b3 n_0767 VDD VDD VSS VSS
+ gf180mcu_fd_sc_mcu7t5v0__xor2_1
Xn_1356 n_0764 n_0767 n_0105 VDD VDD VSS VSS gf180mcu_fd_sc_mcu7t5v0__xnor2_1
Xn_1357 u_cas_int_out_int2_b3 u_cas_int_out_int1_b3 u_cas_int_out_int1_b2 u_cas_int_out_int2_b2
+ n_0768 VDD VDD VSS VSS gf180mcu_fd_sc_mcu7t5v0__oai211_1
Xn_1358 n_0765 n_0768 n_0769 VDD VDD VSS VSS gf180mcu_fd_sc_mcu7t5v0__nand2_1
Xn_1359 n_0764 n_0765 n_0766 n_0770 VDD VDD VSS VSS gf180mcu_fd_sc_mcu7t5v0__aoi21_1
Xn_1360 n_0763 n_0767 n_0769 n_0771 VDD VDD VSS VSS gf180mcu_fd_sc_mcu7t5v0__aoi21_1
Xn_1361 u_cas_int_out_int2_b4 u_cas_int_out_int1_b4 n_0772 VDD VDD VSS VSS
+ gf180mcu_fd_sc_mcu7t5v0__nand2_1
Xn_1362 u_cas_int_out_int2_b4 u_cas_int_out_int1_b4 n_0773 VDD VDD VSS VSS
+ gf180mcu_fd_sc_mcu7t5v0__or2_1
Xn_1363 n_0770 n_0772 n_0773 n_0774 VDD VDD VSS VSS gf180mcu_fd_sc_mcu7t5v0__nand3_1
Xn_1364 u_cas_int_out_int2_b4 u_cas_int_out_int1_b4 n_0770 n_0106 VDD VDD VSS VSS
+ gf180mcu_fd_sc_mcu7t5v0__xor3_1
Xn_1365 n_0772 n_0774 n_0775 VDD VDD VSS VSS gf180mcu_fd_sc_mcu7t5v0__nand2_1
Xn_1366 u_cas_int_out_int2_b5 u_cas_int_out_int1_b5 n_0776 VDD VDD VSS VSS
+ gf180mcu_fd_sc_mcu7t5v0__nor2_1
Xn_1367 u_cas_int_out_int2_b5 u_cas_int_out_int1_b5 n_0777 VDD VDD VSS VSS
+ gf180mcu_fd_sc_mcu7t5v0__nand2_1
Xn_1368 u_cas_int_out_int2_b5 u_cas_int_out_int1_b5 n_0775 n_0107 VDD VDD VSS VSS
+ gf180mcu_fd_sc_mcu7t5v0__xor3_1
Xn_1369 u_cas_int_out_int2_b6 u_cas_int_out_int1_b6 n_0778 VDD VDD VSS VSS
+ gf180mcu_fd_sc_mcu7t5v0__or2_1
Xn_1370 u_cas_int_out_int2_b6 u_cas_int_out_int1_b6 n_0779 VDD VDD VSS VSS
+ gf180mcu_fd_sc_mcu7t5v0__and2_1
Xn_1371 u_cas_int_out_int2_b4 u_cas_int_out_int1_b4 u_cas_int_out_int1_b5 u_cas_int_out_int2_b5
+ n_0780 VDD VDD VSS VSS gf180mcu_fd_sc_mcu7t5v0__aoi22_1
Xn_1372 n_0772 n_0777 n_0776 n_0781 VDD VDD VSS VSS gf180mcu_fd_sc_mcu7t5v0__aoi21_1
Xn_1373 n_0774 n_0780 n_0776 n_0782 VDD VDD VSS VSS gf180mcu_fd_sc_mcu7t5v0__aoi21_1
Xn_1374 u_cas_int_out_int2_b6 u_cas_int_out_int1_b6 n_0782 n_0108 VDD VDD VSS VSS
+ gf180mcu_fd_sc_mcu7t5v0__xor3_1
Xn_1375 n_0782 n_0778 n_0779 n_0783 VDD VDD VSS VSS gf180mcu_fd_sc_mcu7t5v0__aoi21_1
Xn_1376 u_cas_int_out_int2_b7 u_cas_int_out_int1_b7 n_0784 VDD VDD VSS VSS
+ gf180mcu_fd_sc_mcu7t5v0__and2_1
Xn_1377 u_cas_int_out_int2_b7 u_cas_int_out_int1_b7 n_0785 VDD VDD VSS VSS
+ gf180mcu_fd_sc_mcu7t5v0__nand2_1
Xn_1378 u_cas_int_out_int2_b7 n_0498 n_0783 n_0109 VDD VDD VSS VSS gf180mcu_fd_sc_mcu7t5v0__xor3_1
Xn_1379 u_cas_int_out_int2_b6 u_cas_int_out_int1_b6 u_cas_int_out_int1_b7 u_cas_int_out_int2_b7
+ n_0786 VDD VDD VSS VSS gf180mcu_fd_sc_mcu7t5v0__oai22_1
Xn_1380 n_0786 n_0784 n_0779 n_0787 VDD VDD VSS VSS gf180mcu_fd_sc_mcu7t5v0__nor3_1
Xn_1381 u_cas_int_out_int2_b4 u_cas_int_out_int1_b4 u_cas_int_out_int1_b5 u_cas_int_out_int2_b5
+ n_0788 VDD VDD VSS VSS gf180mcu_fd_sc_mcu7t5v0__oai22_1
Xn_1382 u_cas_int_out_int2_b4 u_cas_int_out_int1_b4 n_0788 n_0789 VDD VDD VSS VSS
+ gf180mcu_fd_sc_mcu7t5v0__aoi21_1
Xn_1383 n_0787 n_0789 n_0777 n_0790 VDD VDD VSS VSS gf180mcu_fd_sc_mcu7t5v0__nand3_1
Xn_1384 u_cas_int_out_int2_b7 u_cas_int_out_int1_b7 u_cas_int_out_int1_b6 u_cas_int_out_int2_b6
+ n_0791 VDD VDD VSS VSS gf180mcu_fd_sc_mcu7t5v0__oai211_1
Xn_1385 n_0785 n_0791 n_0792 VDD VDD VSS VSS gf180mcu_fd_sc_mcu7t5v0__nand2_1
Xn_1386 n_0787 n_0781 n_0792 n_0793 VDD VDD VSS VSS gf180mcu_fd_sc_mcu7t5v0__aoi21_1
Xn_1387 n_0771 n_0790 n_0793 n_0794 VDD VDD VSS VSS gf180mcu_fd_sc_mcu7t5v0__oai21_1
Xn_1388 u_cas_int_out_int2_b8 u_cas_int_out_int1_b8 n_0795 VDD VDD VSS VSS
+ gf180mcu_fd_sc_mcu7t5v0__nand2_1
Xn_1389 u_cas_int_out_int2_b8 u_cas_int_out_int1_b8 n_0796 VDD VDD VSS VSS
+ gf180mcu_fd_sc_mcu7t5v0__or2_1
Xn_1390 n_0794 n_0795 n_0796 n_0797 VDD VDD VSS VSS gf180mcu_fd_sc_mcu7t5v0__nand3_1
Xn_1391 u_cas_int_out_int2_b8 u_cas_int_out_int1_b8 n_0794 n_0110 VDD VDD VSS VSS
+ gf180mcu_fd_sc_mcu7t5v0__xor3_1
Xn_1392 n_0795 n_0797 n_0798 VDD VDD VSS VSS gf180mcu_fd_sc_mcu7t5v0__nand2_1
Xn_1393 u_cas_int_out_int2_b9 u_cas_int_out_int1_b9 n_0799 VDD VDD VSS VSS
+ gf180mcu_fd_sc_mcu7t5v0__or2_1
Xn_1394 u_cas_int_out_int2_b9 u_cas_int_out_int1_b9 n_0800 VDD VDD VSS VSS
+ gf180mcu_fd_sc_mcu7t5v0__nand2_1
Xn_1395 u_cas_int_out_int2_b9 u_cas_int_out_int1_b9 n_0798 n_0111 VDD VDD VSS VSS
+ gf180mcu_fd_sc_mcu7t5v0__xor3_1
Xn_1396 n_0795 n_0796 n_0799 n_0800 n_0801 VDD VDD VSS VSS gf180mcu_fd_sc_mcu7t5v0__nand4_1
Xn_1397 n_0801 n_0802 VDD VDD VSS VSS gf180mcu_fd_sc_mcu7t5v0__clkinv_1
Xn_1398 u_cas_int_out_int2_b9 u_cas_int_out_int1_b9 u_cas_int_out_int1_b8 u_cas_int_out_int2_b8
+ n_0803 VDD VDD VSS VSS gf180mcu_fd_sc_mcu7t5v0__oai211_1
Xn_1399 n_0800 n_0803 n_0804 VDD VDD VSS VSS gf180mcu_fd_sc_mcu7t5v0__nand2_1
Xn_1400 n_0794 n_0802 n_0804 n_0805 VDD VDD VSS VSS gf180mcu_fd_sc_mcu7t5v0__aoi21_1
Xn_1401 u_cas_int_out_int2_b10 u_cas_int_out_int1_b10 n_0806 VDD VDD VSS VSS
+ gf180mcu_fd_sc_mcu7t5v0__nor2_1
Xn_1402 u_cas_int_out_int2_b10 u_cas_int_out_int1_b10 n_0807 VDD VDD VSS VSS
+ gf180mcu_fd_sc_mcu7t5v0__and2_1
Xn_1403 u_cas_int_out_int2_b10 u_cas_int_out_int1_b10 n_0808 VDD VDD VSS VSS
+ gf180mcu_fd_sc_mcu7t5v0__nand2_1
Xn_1404 u_cas_int_out_int2_b10 u_cas_int_out_int1_b10 n_0805 n_0088 VDD VDD VSS VSS
+ gf180mcu_fd_sc_mcu7t5v0__xnor3_1
Xn_1405 n_0805 n_0806 n_0808 n_0809 VDD VDD VSS VSS gf180mcu_fd_sc_mcu7t5v0__oai21_1
Xn_1406 u_cas_int_out_int2_b11 u_cas_int_out_int1_b11 n_0810 VDD VDD VSS VSS
+ gf180mcu_fd_sc_mcu7t5v0__nand2_1
Xn_1407 u_cas_int_out_int2_b11 u_cas_int_out_int1_b11 n_0809 n_0089 VDD VDD VSS VSS
+ gf180mcu_fd_sc_mcu7t5v0__xor3_1
Xn_1408 u_cas_int_out_int2_b10 u_cas_int_out_int1_b10 u_cas_int_out_int1_b11 u_cas_int_out_int2_b11
+ n_0811 VDD VDD VSS VSS gf180mcu_fd_sc_mcu7t5v0__oai22_1
Xn_1409 n_0811 n_0807 n_0812 VDD VDD VSS VSS gf180mcu_fd_sc_mcu7t5v0__nor2_1
Xn_1410 n_0812 n_0810 n_0813 VDD VDD VSS VSS gf180mcu_fd_sc_mcu7t5v0__nand2_1
Xn_1411 n_0801 n_0813 n_0814 VDD VDD VSS VSS gf180mcu_fd_sc_mcu7t5v0__nor2_1
Xn_1412 n_0794 n_0814 n_0815 VDD VDD VSS VSS gf180mcu_fd_sc_mcu7t5v0__nand2_1
Xn_1413 u_cas_int_out_int2_b11 u_cas_int_out_int1_b11 u_cas_int_out_int1_b10 u_cas_int_out_int2_b10
+ n_0816 VDD VDD VSS VSS gf180mcu_fd_sc_mcu7t5v0__oai211_1
Xn_1414 n_0810 n_0816 n_0817 VDD VDD VSS VSS gf180mcu_fd_sc_mcu7t5v0__nand2_1
Xn_1415 n_0804 n_0812 n_0817 n_0818 VDD VDD VSS VSS gf180mcu_fd_sc_mcu7t5v0__aoi21_1
Xn_1416 n_0815 n_0818 n_0819 VDD VDD VSS VSS gf180mcu_fd_sc_mcu7t5v0__nand2_1
Xn_1417 u_cas_int_out_int2_b12 u_cas_int_out_int1_b12 n_0820 VDD VDD VSS VSS
+ gf180mcu_fd_sc_mcu7t5v0__nand2_1
Xn_1418 u_cas_int_out_int2_b12 u_cas_int_out_int1_b12 n_0821 VDD VDD VSS VSS
+ gf180mcu_fd_sc_mcu7t5v0__or2_1
Xn_1419 n_0820 n_0821 n_0822 VDD VDD VSS VSS gf180mcu_fd_sc_mcu7t5v0__nand2_1
Xn_1420 n_0815 n_0818 n_0822 n_0823 VDD VDD VSS VSS gf180mcu_fd_sc_mcu7t5v0__aoi21_1
Xn_1421 n_0819 n_0822 n_0090 VDD VDD VSS VSS gf180mcu_fd_sc_mcu7t5v0__xnor2_1
Xn_1422 u_cas_int_out_int2_b13 u_cas_int_out_int1_b13 n_0824 VDD VDD VSS VSS
+ gf180mcu_fd_sc_mcu7t5v0__or2_1
Xn_1423 u_cas_int_out_int2_b13 u_cas_int_out_int1_b13 n_0825 VDD VDD VSS VSS
+ gf180mcu_fd_sc_mcu7t5v0__nand2_1
Xn_1424 u_cas_int_out_int2_b12 u_cas_int_out_int1_b12 n_0823 n_0826 VDD VDD VSS VSS
+ gf180mcu_fd_sc_mcu7t5v0__aoi21_1
Xn_1425 u_cas_int_out_int2_b13 u_cas_int_out_int1_b13 n_0826 n_0091 VDD VDD VSS VSS
+ gf180mcu_fd_sc_mcu7t5v0__xnor3_1
Xn_1426 u_cas_int_out_int2_b14 u_cas_int_out_int1_b14 n_0827 VDD VDD VSS VSS
+ gf180mcu_fd_sc_mcu7t5v0__nand2_1
Xn_1427 u_cas_int_out_int2_b14 u_cas_int_out_int1_b14 n_0828 VDD VDD VSS VSS
+ gf180mcu_fd_sc_mcu7t5v0__xor2_1
Xn_1428 n_0820 n_0825 n_0829 VDD VDD VSS VSS gf180mcu_fd_sc_mcu7t5v0__nand2_1
Xn_1429 n_0824 n_0829 n_0830 VDD VDD VSS VSS gf180mcu_fd_sc_mcu7t5v0__nand2_1
Xn_1430 n_0823 n_0829 u_cas_int_out_int2_b13 u_cas_int_out_int1_b13 n_0831 VDD VDD VSS VSS
+ gf180mcu_fd_sc_mcu7t5v0__oai22_1
Xn_1431 n_0823 n_0829 n_0828 n_0824 n_0832 VDD VDD VSS VSS gf180mcu_fd_sc_mcu7t5v0__oai211_1
Xn_1432 n_0828 n_0831 n_0092 VDD VDD VSS VSS gf180mcu_fd_sc_mcu7t5v0__xnor2_1
Xn_1433 u_cas_int_out_int2_b15 u_cas_int_out_int1_b15 n_0833 VDD VDD VSS VSS
+ gf180mcu_fd_sc_mcu7t5v0__nor2_1
Xn_1434 u_cas_int_out_int2_b15 u_cas_int_out_int1_b15 n_0834 VDD VDD VSS VSS
+ gf180mcu_fd_sc_mcu7t5v0__nand2_1
Xn_1435 u_cas_int_out_int2_b15 u_cas_int_out_int1_b15 n_0835 VDD VDD VSS VSS
+ gf180mcu_fd_sc_mcu7t5v0__xor2_1
Xn_1436 n_0827 n_0832 n_0836 VDD VDD VSS VSS gf180mcu_fd_sc_mcu7t5v0__nand2_1
Xn_1437 n_0835 n_0836 n_0093 VDD VDD VSS VSS gf180mcu_fd_sc_mcu7t5v0__xor2_1
Xn_1438 n_0828 n_0835 n_0837 VDD VDD VSS VSS gf180mcu_fd_sc_mcu7t5v0__nand2_1
Xn_1439 n_0837 n_0838 VDD VDD VSS VSS gf180mcu_fd_sc_mcu7t5v0__clkinv_1
Xn_1440 n_0820 n_0821 n_0824 n_0825 n_0839 VDD VDD VSS VSS gf180mcu_fd_sc_mcu7t5v0__nand4_1
Xn_1441 n_0818 n_0839 n_0830 n_0840 VDD VDD VSS VSS gf180mcu_fd_sc_mcu7t5v0__oai21_1
Xn_1442 n_0833 n_0827 n_0834 n_0841 VDD VDD VSS VSS gf180mcu_fd_sc_mcu7t5v0__oai21_1
Xn_1443 n_0840 n_0838 n_0841 n_0842 VDD VDD VSS VSS gf180mcu_fd_sc_mcu7t5v0__aoi21_1
Xn_1444 n_0801 n_0813 n_0837 n_0839 n_0843 VDD VDD VSS VSS gf180mcu_fd_sc_mcu7t5v0__nor4_1
Xn_1445 n_0794 n_0843 n_0844 VDD VDD VSS VSS gf180mcu_fd_sc_mcu7t5v0__nand2_1
Xn_1446 n_0844 n_0842 n_0845 VDD VDD VSS VSS gf180mcu_fd_sc_mcu7t5v0__and2_1
Xn_1447 n_0844 n_0842 n_0846 VDD VDD VSS VSS gf180mcu_fd_sc_mcu7t5v0__nand2_1
Xn_1448 u_cas_int_out_int2_b16 u_cas_int_out_int1_b16 n_0847 VDD VDD VSS VSS
+ gf180mcu_fd_sc_mcu7t5v0__or2_1
Xn_1449 u_cas_int_out_int2_b16 u_cas_int_out_int1_b16 n_0848 VDD VDD VSS VSS
+ gf180mcu_fd_sc_mcu7t5v0__nand2_1
Xn_1450 n_0847 n_0848 n_0849 VDD VDD VSS VSS gf180mcu_fd_sc_mcu7t5v0__nand2_1
Xn_1451 n_0844 n_0842 n_0849 n_0850 VDD VDD VSS VSS gf180mcu_fd_sc_mcu7t5v0__aoi21_1
Xn_1452 n_0845 n_0849 n_0094 VDD VDD VSS VSS gf180mcu_fd_sc_mcu7t5v0__xor2_1
Xn_1453 u_cas_int_out_int2_b16 u_cas_int_out_int1_b16 n_0850 n_0851 VDD VDD VSS VSS
+ gf180mcu_fd_sc_mcu7t5v0__aoi21_1
Xn_1454 u_cas_int_out_int2_b17 u_cas_int_out_int1_b17 n_0852 VDD VDD VSS VSS
+ gf180mcu_fd_sc_mcu7t5v0__or2_1
Xn_1455 u_cas_int_out_int2_b17 u_cas_int_out_int1_b17 n_0853 VDD VDD VSS VSS
+ gf180mcu_fd_sc_mcu7t5v0__nand2_1
Xn_1456 n_0852 n_0853 n_0854 VDD VDD VSS VSS gf180mcu_fd_sc_mcu7t5v0__nand2_1
Xn_1457 n_0851 n_0854 n_0095 VDD VDD VSS VSS gf180mcu_fd_sc_mcu7t5v0__xor2_1
Xn_1458 n_0848 n_0853 n_0855 VDD VDD VSS VSS gf180mcu_fd_sc_mcu7t5v0__nand2_1
Xn_1459 n_0850 n_0855 u_cas_int_out_int2_b17 u_cas_int_out_int1_b17 n_0856 VDD VDD VSS VSS
+ gf180mcu_fd_sc_mcu7t5v0__oai22_1
Xn_1460 u_cas_int_out_int2_b18 u_cas_int_out_int1_b18 n_0857 VDD VDD VSS VSS
+ gf180mcu_fd_sc_mcu7t5v0__nand2_1
Xn_1461 u_cas_int_out_int2_b18 u_cas_int_out_int1_b18 n_0858 VDD VDD VSS VSS
+ gf180mcu_fd_sc_mcu7t5v0__xor2_1
Xn_1462 n_0850 n_0855 n_0858 n_0852 n_0859 VDD VDD VSS VSS gf180mcu_fd_sc_mcu7t5v0__oai211_1
Xn_1463 n_0856 n_0858 n_0096 VDD VDD VSS VSS gf180mcu_fd_sc_mcu7t5v0__xnor2_1
Xn_1464 u_cas_int_out_int2_b19 u_cas_int_out_int1_b19 n_0860 VDD VDD VSS VSS
+ gf180mcu_fd_sc_mcu7t5v0__nand2_1
Xn_1465 u_cas_int_out_int2_b19 u_cas_int_out_int1_b19 n_0861 VDD VDD VSS VSS
+ gf180mcu_fd_sc_mcu7t5v0__xor2_1
Xn_1466 n_0857 n_0859 n_0862 VDD VDD VSS VSS gf180mcu_fd_sc_mcu7t5v0__nand2_1
Xn_1467 n_0861 n_0862 n_0097 VDD VDD VSS VSS gf180mcu_fd_sc_mcu7t5v0__xor2_1
Xn_1468 n_0858 n_0861 n_0863 VDD VDD VSS VSS gf180mcu_fd_sc_mcu7t5v0__nand2_1
Xn_1469 n_0849 n_0854 n_0863 n_0864 VDD VDD VSS VSS gf180mcu_fd_sc_mcu7t5v0__nor3_1
Xn_1470 n_0864 n_0865 VDD VDD VSS VSS gf180mcu_fd_sc_mcu7t5v0__clkinv_1
Xn_1471 n_0844 n_0842 n_0865 n_0866 VDD VDD VSS VSS gf180mcu_fd_sc_mcu7t5v0__aoi21_1
Xn_1472 n_0858 n_0861 n_0852 n_0855 n_0867 VDD VDD VSS VSS gf180mcu_fd_sc_mcu7t5v0__nand4_1
Xn_1473 u_cas_int_out_int2_b19 u_cas_int_out_int1_b19 u_cas_int_out_int1_b18 u_cas_int_out_int2_b18
+ n_0868 VDD VDD VSS VSS gf180mcu_fd_sc_mcu7t5v0__oai211_1
Xn_1474 n_0860 n_0867 n_0868 n_0869 VDD VDD VSS VSS gf180mcu_fd_sc_mcu7t5v0__and3_1
Xn_1475 n_0860 n_0867 n_0868 n_0870 VDD VDD VSS VSS gf180mcu_fd_sc_mcu7t5v0__nand3_1
Xn_1476 n_0846 n_0864 n_0870 n_0871 VDD VDD VSS VSS gf180mcu_fd_sc_mcu7t5v0__aoi21_1
Xn_1477 n_0845 n_0865 n_0869 n_0872 VDD VDD VSS VSS gf180mcu_fd_sc_mcu7t5v0__oai21_1
Xn_1478 u_cas_int_out_int2_b20 u_cas_int_out_int1_b20 n_0873 VDD VDD VSS VSS
+ gf180mcu_fd_sc_mcu7t5v0__or2_1
Xn_1479 u_cas_int_out_int2_b20 u_cas_int_out_int1_b20 n_0874 VDD VDD VSS VSS
+ gf180mcu_fd_sc_mcu7t5v0__nand2_1
Xn_1480 n_0873 n_0874 n_0875 VDD VDD VSS VSS gf180mcu_fd_sc_mcu7t5v0__nand2_1
Xn_1481 n_0871 n_0875 n_0099 VDD VDD VSS VSS gf180mcu_fd_sc_mcu7t5v0__xor2_1
Xn_1482 u_cas_int_out_int2_b21 u_cas_int_out_int1_b21 n_0876 VDD VDD VSS VSS
+ gf180mcu_fd_sc_mcu7t5v0__or2_1
Xn_1483 u_cas_int_out_int2_b21 u_cas_int_out_int1_b21 n_0877 VDD VDD VSS VSS
+ gf180mcu_fd_sc_mcu7t5v0__nand2_1
Xn_1484 n_0871 n_0875 n_0874 n_0878 VDD VDD VSS VSS gf180mcu_fd_sc_mcu7t5v0__oai21_1
Xn_1485 u_cas_int_out_int2_b21 u_cas_int_out_int1_b21 n_0878 n_0100 VDD VDD VSS VSS
+ gf180mcu_fd_sc_mcu7t5v0__xor3_1
Xn_1486 n_0873 n_0874 n_0876 n_0877 n_0879 VDD VDD VSS VSS gf180mcu_fd_sc_mcu7t5v0__and4_1
Xn_1487 n_0866 n_0870 n_0879 n_0880 VDD VDD VSS VSS gf180mcu_fd_sc_mcu7t5v0__oai21_1
Xn_1488 n_0876 u_cas_int_out_int1_b20 u_cas_int_out_int2_b20 n_0881 VDD VDD VSS VSS
+ gf180mcu_fd_sc_mcu7t5v0__nand3_1
Xn_1489 n_0877 n_0881 n_0882 VDD VDD VSS VSS gf180mcu_fd_sc_mcu7t5v0__and2_1
Xn_1490 n_0877 n_0881 n_0883 VDD VDD VSS VSS gf180mcu_fd_sc_mcu7t5v0__nand2_1
Xn_1491 n_0872 n_0879 n_0883 n_0884 VDD VDD VSS VSS gf180mcu_fd_sc_mcu7t5v0__aoi21_1
Xn_1492 n_0880 n_0882 n_0885 VDD VDD VSS VSS gf180mcu_fd_sc_mcu7t5v0__nand2_1
Xn_1493 u_cas_int_out_int2_b22 u_cas_int_out_int1_b22 n_0886 VDD VDD VSS VSS
+ gf180mcu_fd_sc_mcu7t5v0__nor2_1
Xn_1494 u_cas_int_out_int2_b22 u_cas_int_out_int1_b22 n_0887 VDD VDD VSS VSS
+ gf180mcu_fd_sc_mcu7t5v0__and2_1
Xn_1495 u_cas_int_out_int2_b22 u_cas_int_out_int1_b22 n_0888 VDD VDD VSS VSS
+ gf180mcu_fd_sc_mcu7t5v0__nand2_1
Xn_1496 u_cas_int_out_int2_b22 u_cas_int_out_int1_b22 n_0885 n_0101 VDD VDD VSS VSS
+ gf180mcu_fd_sc_mcu7t5v0__xor3_1
Xn_1497 u_cas_int_out_int2_b23 u_cas_int_out_int1_b23 n_0889 VDD VDD VSS VSS
+ gf180mcu_fd_sc_mcu7t5v0__or2_1
Xn_1498 u_cas_int_out_int2_b23 u_cas_int_out_int1_b23 n_0890 VDD VDD VSS VSS
+ gf180mcu_fd_sc_mcu7t5v0__nand2_1
Xn_1499 n_0889 n_0890 n_0891 VDD VDD VSS VSS gf180mcu_fd_sc_mcu7t5v0__and2_1
Xn_1500 n_0889 n_0890 n_0892 VDD VDD VSS VSS gf180mcu_fd_sc_mcu7t5v0__nand2_1
Xn_1501 n_0880 n_0882 n_0886 n_0893 VDD VDD VSS VSS gf180mcu_fd_sc_mcu7t5v0__aoi21_1
Xn_1502 n_0887 n_0893 n_0892 n_0894 VDD VDD VSS VSS gf180mcu_fd_sc_mcu7t5v0__oai21_1
Xn_1503 n_0884 n_0886 n_0888 n_0891 n_0895 VDD VDD VSS VSS gf180mcu_fd_sc_mcu7t5v0__oai211_1
Xn_1504 n_0894 n_0895 n_0102 VDD VDD VSS VSS gf180mcu_fd_sc_mcu7t5v0__nand2_1
Xn_1505 n_0892 n_0887 n_0886 n_0896 VDD VDD VSS VSS gf180mcu_fd_sc_mcu7t5v0__nor3_1
Xn_1506 n_0896 n_0897 VDD VDD VSS VSS gf180mcu_fd_sc_mcu7t5v0__clkinv_1
Xn_1507 n_0880 n_0882 n_0897 n_0898 VDD VDD VSS VSS gf180mcu_fd_sc_mcu7t5v0__aoi21_1
Xn_1508 n_0889 u_cas_int_out_int1_b22 u_cas_int_out_int2_b22 n_0899 VDD VDD VSS VSS
+ gf180mcu_fd_sc_mcu7t5v0__nand3_1
Xn_1509 n_0890 n_0899 n_0900 VDD VDD VSS VSS gf180mcu_fd_sc_mcu7t5v0__and2_1
Xn_1510 n_0890 n_0899 n_0901 VDD VDD VSS VSS gf180mcu_fd_sc_mcu7t5v0__nand2_1
Xn_1511 u_cas_int_out_int2_b24 u_cas_int_out_int1_b24 n_0902 VDD VDD VSS VSS
+ gf180mcu_fd_sc_mcu7t5v0__xnor2_1
Xn_1512 u_cas_int_out_int2_b24 u_cas_int_out_int1_b24 n_0903 VDD VDD VSS VSS
+ gf180mcu_fd_sc_mcu7t5v0__xor2_1
Xn_1513 n_0884 n_0897 n_0900 n_0903 n_0904 VDD VDD VSS VSS gf180mcu_fd_sc_mcu7t5v0__oai211_1
Xn_1514 n_0898 n_0901 n_0902 n_0905 VDD VDD VSS VSS gf180mcu_fd_sc_mcu7t5v0__oai21_1
Xn_1515 n_0904 n_0905 n_0103 VDD VDD VSS VSS gf180mcu_fd_sc_mcu7t5v0__nand2_1
Xn_1516 u_cas_int_out_int1_b0 net1 n_0906 VDD VDD VSS VSS gf180mcu_fd_sc_mcu7t5v0__nand2_1
Xn_1517 u_cas_int_out_int1_b1 u_cas_int_out_int1_b0 net1 n_0907 VDD VDD VSS VSS
+ gf180mcu_fd_sc_mcu7t5v0__nand3_1
Xn_1518 u_cas_int_out_int1_b1 n_0906 n_0073 VDD VDD VSS VSS gf180mcu_fd_sc_mcu7t5v0__xnor2_1
Xn_1519 u_cas_int_out_int1_b1 u_cas_int_out_int1_b0 u_cas_int_out_int1_b2 net1 n_0908 VDD VDD VSS
+ VSS gf180mcu_fd_sc_mcu7t5v0__and4_1
Xn_1520 u_cas_int_out_int1_b2 n_0907 n_0079 VDD VDD VSS VSS gf180mcu_fd_sc_mcu7t5v0__xnor2_1
Xn_1521 u_cas_int_out_int1_b3 n_0908 n_0909 VDD VDD VSS VSS gf180mcu_fd_sc_mcu7t5v0__nand2_1
Xn_1522 u_cas_int_out_int1_b3 n_0908 n_0080 VDD VDD VSS VSS gf180mcu_fd_sc_mcu7t5v0__xor2_1
Xn_1523 u_cas_int_out_int1_b3 u_cas_int_out_int1_b4 n_0908 n_0910 VDD VDD VSS VSS
+ gf180mcu_fd_sc_mcu7t5v0__nand3_1
Xn_1524 u_cas_int_out_int1_b4 n_0909 n_0081 VDD VDD VSS VSS gf180mcu_fd_sc_mcu7t5v0__xnor2_1
Xn_1525 u_cas_int_out_int1_b3 u_cas_int_out_int1_b4 u_cas_int_out_int1_b5 n_0908 n_0911 VDD VDD VSS
+ VSS gf180mcu_fd_sc_mcu7t5v0__and4_1
Xn_1526 u_cas_int_out_int1_b3 u_cas_int_out_int1_b4 u_cas_int_out_int1_b5 n_0908 n_0912 VDD VDD VSS
+ VSS gf180mcu_fd_sc_mcu7t5v0__nand4_1
Xn_1527 u_cas_int_out_int1_b5 n_0910 n_0082 VDD VDD VSS VSS gf180mcu_fd_sc_mcu7t5v0__xnor2_1
Xn_1528 n_0497 n_0912 n_0083 VDD VDD VSS VSS gf180mcu_fd_sc_mcu7t5v0__xor2_1
Xn_1529 u_cas_int_out_int1_b6 n_0911 u_cas_int_out_int1_b7 n_0913 VDD VDD VSS VSS
+ gf180mcu_fd_sc_mcu7t5v0__aoi21_1
Xn_1530 n_0497 n_0498 n_0912 n_0914 VDD VDD VSS VSS gf180mcu_fd_sc_mcu7t5v0__nor3_1
Xn_1531 n_0913 n_0914 n_0084 VDD VDD VSS VSS gf180mcu_fd_sc_mcu7t5v0__nor2_1
Xn_1532 u_cas_int_out_int1_b8 n_0914 n_0085 VDD VDD VSS VSS gf180mcu_fd_sc_mcu7t5v0__xor2_1
Xn_1533 u_cas_int_out_int1_b8 n_0914 u_cas_int_out_int1_b9 n_0915 VDD VDD VSS VSS
+ gf180mcu_fd_sc_mcu7t5v0__aoi21_1
Xn_1534 u_cas_int_out_int1_b8 u_cas_int_out_int1_b9 n_0916 VDD VDD VSS VSS
+ gf180mcu_fd_sc_mcu7t5v0__and2_1
Xn_1535 n_0914 n_0916 n_0915 n_0086 VDD VDD VSS VSS gf180mcu_fd_sc_mcu7t5v0__aoi21_1
Xn_1536 n_0914 n_0916 u_cas_int_out_int1_b10 n_0917 VDD VDD VSS VSS gf180mcu_fd_sc_mcu7t5v0__aoi21_1
Xn_1537 u_cas_int_out_int1_b8 u_cas_int_out_int1_b9 u_cas_int_out_int1_b10 n_0914 n_0918 VDD VDD VSS
+ VSS gf180mcu_fd_sc_mcu7t5v0__and4_1
Xn_1538 n_0917 n_0918 n_0063 VDD VDD VSS VSS gf180mcu_fd_sc_mcu7t5v0__nor2_1
Xn_1539 u_cas_int_out_int1_b11 n_0918 n_0919 VDD VDD VSS VSS gf180mcu_fd_sc_mcu7t5v0__nor2_1
Xn_1540 u_cas_int_out_int1_b10 u_cas_int_out_int1_b11 n_0914 n_0916 n_0920 VDD VDD VSS VSS
+ gf180mcu_fd_sc_mcu7t5v0__and4_1
Xn_1541 n_0919 n_0920 n_0064 VDD VDD VSS VSS gf180mcu_fd_sc_mcu7t5v0__nor2_1
Xn_1542 u_cas_int_out_int1_b12 n_0920 n_0065 VDD VDD VSS VSS gf180mcu_fd_sc_mcu7t5v0__xor2_1
Xn_1543 u_cas_int_out_int1_b12 n_0920 u_cas_int_out_int1_b13 n_0921 VDD VDD VSS VSS
+ gf180mcu_fd_sc_mcu7t5v0__aoi21_1
Xn_1544 u_cas_int_out_int1_b12 u_cas_int_out_int1_b13 n_0922 VDD VDD VSS VSS
+ gf180mcu_fd_sc_mcu7t5v0__and2_1
Xn_1545 n_0920 n_0922 n_0921 n_0066 VDD VDD VSS VSS gf180mcu_fd_sc_mcu7t5v0__aoi21_1
Xn_1546 n_0920 n_0922 u_cas_int_out_int1_b14 n_0923 VDD VDD VSS VSS gf180mcu_fd_sc_mcu7t5v0__aoi21_1
Xn_1547 u_cas_int_out_int1_b12 u_cas_int_out_int1_b13 u_cas_int_out_int1_b14 n_0920 n_0924 VDD VDD
+ VSS VSS gf180mcu_fd_sc_mcu7t5v0__and4_1
Xn_1548 n_0923 n_0924 n_0067 VDD VDD VSS VSS gf180mcu_fd_sc_mcu7t5v0__nor2_1
Xn_1549 u_cas_int_out_int1_b15 n_0924 n_0925 VDD VDD VSS VSS gf180mcu_fd_sc_mcu7t5v0__nor2_1
Xn_1550 u_cas_int_out_int1_b11 u_cas_int_out_int1_b14 u_cas_int_out_int1_b15 n_0922 n_0926 VDD VDD
+ VSS VSS gf180mcu_fd_sc_mcu7t5v0__and4_1
Xn_1551 u_cas_int_out_int1_b10 n_0914 n_0916 n_0926 n_0927 VDD VDD VSS VSS
+ gf180mcu_fd_sc_mcu7t5v0__and4_1
Xn_1552 n_0918 n_0926 n_0925 n_0068 VDD VDD VSS VSS gf180mcu_fd_sc_mcu7t5v0__aoi21_1
Xn_1553 u_cas_int_out_int1_b16 n_0927 n_0069 VDD VDD VSS VSS gf180mcu_fd_sc_mcu7t5v0__xor2_1
Xn_1554 u_cas_int_out_int1_b16 n_0927 u_cas_int_out_int1_b17 n_0928 VDD VDD VSS VSS
+ gf180mcu_fd_sc_mcu7t5v0__aoi21_1
Xn_1555 u_cas_int_out_int1_b16 u_cas_int_out_int1_b17 n_0929 VDD VDD VSS VSS
+ gf180mcu_fd_sc_mcu7t5v0__and2_1
Xn_1556 n_0927 n_0929 n_0928 n_0070 VDD VDD VSS VSS gf180mcu_fd_sc_mcu7t5v0__aoi21_1
Xn_1557 n_0927 n_0929 u_cas_int_out_int1_b18 n_0930 VDD VDD VSS VSS gf180mcu_fd_sc_mcu7t5v0__aoi21_1
Xn_1558 u_cas_int_out_int1_b16 u_cas_int_out_int1_b17 u_cas_int_out_int1_b18 n_0927 n_0931 VDD VDD
+ VSS VSS gf180mcu_fd_sc_mcu7t5v0__and4_1
Xn_1559 n_0930 n_0931 n_0071 VDD VDD VSS VSS gf180mcu_fd_sc_mcu7t5v0__nor2_1
Xn_1560 u_cas_int_out_int1_b19 n_0931 n_0932 VDD VDD VSS VSS gf180mcu_fd_sc_mcu7t5v0__nor2_1
Xn_1561 u_cas_int_out_int1_b18 u_cas_int_out_int1_b19 n_0927 n_0929 n_0933 VDD VDD VSS VSS
+ gf180mcu_fd_sc_mcu7t5v0__and4_1
Xn_1562 n_0932 n_0933 n_0072 VDD VDD VSS VSS gf180mcu_fd_sc_mcu7t5v0__nor2_1
Xn_1563 u_cas_int_out_int1_b20 n_0933 n_0074 VDD VDD VSS VSS gf180mcu_fd_sc_mcu7t5v0__xor2_1
Xn_1564 u_cas_int_out_int1_b20 n_0933 u_cas_int_out_int1_b21 n_0934 VDD VDD VSS VSS
+ gf180mcu_fd_sc_mcu7t5v0__aoi21_1
Xn_1565 u_cas_int_out_int1_b20 u_cas_int_out_int1_b21 n_0933 n_0935 VDD VDD VSS VSS
+ gf180mcu_fd_sc_mcu7t5v0__and3_1
Xn_1566 u_cas_int_out_int1_b20 u_cas_int_out_int1_b21 n_0933 n_0936 VDD VDD VSS VSS
+ gf180mcu_fd_sc_mcu7t5v0__nand3_1
Xn_1567 n_0934 n_0935 n_0075 VDD VDD VSS VSS gf180mcu_fd_sc_mcu7t5v0__nor2_1
Xn_1568 u_cas_int_out_int1_b22 n_0935 n_0076 VDD VDD VSS VSS gf180mcu_fd_sc_mcu7t5v0__xor2_1
Xn_1569 u_cas_int_out_int1_b22 n_0935 u_cas_int_out_int1_b23 n_0937 VDD VDD VSS VSS
+ gf180mcu_fd_sc_mcu7t5v0__aoi21_1
Xn_1570 u_cas_int_out_int1_b22 u_cas_int_out_int1_b23 n_0938 VDD VDD VSS VSS
+ gf180mcu_fd_sc_mcu7t5v0__nand2_1
Xn_1571 n_0936 n_0938 n_0939 VDD VDD VSS VSS gf180mcu_fd_sc_mcu7t5v0__nor2_1
Xn_1572 n_0937 n_0939 n_0077 VDD VDD VSS VSS gf180mcu_fd_sc_mcu7t5v0__nor2_1
Xn_1573 n_0936 n_0938 u_cas_int_out_int1_b24 n_0940 VDD VDD VSS VSS gf180mcu_fd_sc_mcu7t5v0__oai21_1
Xn_1574 n_0936 n_0938 u_cas_int_out_int1_b24 n_0941 VDD VDD VSS VSS gf180mcu_fd_sc_mcu7t5v0__or3_1
Xn_1575 n_0940 n_0941 n_0078 VDD VDD VSS VSS gf180mcu_fd_sc_mcu7t5v0__nand2_1
Xn_1576 n_0499 u_cas_diff_out_diff2_b13 n_0942 VDD VDD VSS VSS gf180mcu_fd_sc_mcu7t5v0__nand2_1
Xn_1577 n_0499 u_cas_diff_out_diff2_b13 n_0943 VDD VDD VSS VSS gf180mcu_fd_sc_mcu7t5v0__or2_1
Xn_1578 n_0500 u_cas_diff_out_diff2_b12 n_0944 VDD VDD VSS VSS gf180mcu_fd_sc_mcu7t5v0__nor2_1
Xn_1579 n_0500 u_cas_diff_out_diff2_b12 n_0945 VDD VDD VSS VSS gf180mcu_fd_sc_mcu7t5v0__nand2_1
Xn_1580 n_0512 u_cas_diff_out_diff2_b3 n_0514 u_cas_diff_out_diff2_b2 n_0946 VDD VDD VSS VSS
+ gf180mcu_fd_sc_mcu7t5v0__aoi22_1
Xn_1581 n_0515 u_cas_diff_out_diff2_b1 n_0516 u_cas_diff_out_diff2_b0 n_0947 VDD VDD VSS VSS
+ gf180mcu_fd_sc_mcu7t5v0__aoi211_1
Xn_1582 n_0514 u_cas_diff_out_diff2_b2 n_0515 u_cas_diff_out_diff2_b1 n_0948 VDD VDD VSS VSS
+ gf180mcu_fd_sc_mcu7t5v0__oai22_1
Xn_1583 n_0947 n_0948 n_0946 n_0949 VDD VDD VSS VSS gf180mcu_fd_sc_mcu7t5v0__oai21_1
Xn_1584 u_cas_diff_out_diff2_b7 n_0506 n_0507 u_cas_diff_out_diff2_b6 n_0950 VDD VDD VSS VSS
+ gf180mcu_fd_sc_mcu7t5v0__aoi22_1
Xn_1585 n_0506 u_cas_diff_out_diff2_b7 n_0951 VDD VDD VSS VSS gf180mcu_fd_sc_mcu7t5v0__nor2_1
Xn_1586 n_0505 u_cas_diff_u_diff3_in_min1_b7 n_0508 u_cas_diff_u_diff3_in_min1_b6 n_0952 VDD VDD VSS
+ VSS gf180mcu_fd_sc_mcu7t5v0__aoi22_1
Xn_1587 n_0950 n_0952 n_0953 VDD VDD VSS VSS gf180mcu_fd_sc_mcu7t5v0__and2_1
Xn_1588 n_0509 u_cas_diff_out_diff2_b5 n_0511 u_cas_diff_out_diff2_b4 n_0954 VDD VDD VSS VSS
+ gf180mcu_fd_sc_mcu7t5v0__aoi22_1
Xn_1589 n_0511 u_cas_diff_out_diff2_b4 n_0955 VDD VDD VSS VSS gf180mcu_fd_sc_mcu7t5v0__or2_1
Xn_1590 u_cas_diff_u_diff3_in_min1_b5 n_0510 n_0513 u_cas_diff_u_diff3_in_min1_b3 n_0956 VDD VDD VSS
+ VSS gf180mcu_fd_sc_mcu7t5v0__aoi22_1
Xn_1591 n_0954 n_0956 n_0955 n_0957 VDD VDD VSS VSS gf180mcu_fd_sc_mcu7t5v0__and3_1
Xn_1592 n_0949 n_0953 n_0957 n_0958 VDD VDD VSS VSS gf180mcu_fd_sc_mcu7t5v0__nand3_1
Xn_1593 n_0950 n_0951 n_0959 VDD VDD VSS VSS gf180mcu_fd_sc_mcu7t5v0__nor2_1
Xn_1594 u_cas_diff_u_diff3_in_min1_b5 n_0510 n_0954 n_0960 VDD VDD VSS VSS
+ gf180mcu_fd_sc_mcu7t5v0__aoi21_1
Xn_1595 n_0953 n_0960 n_0959 n_0961 VDD VDD VSS VSS gf180mcu_fd_sc_mcu7t5v0__aoi21_1
Xn_1596 n_0958 n_0961 n_0962 VDD VDD VSS VSS gf180mcu_fd_sc_mcu7t5v0__nand2_1
Xn_1597 u_cas_diff_out_diff2_b11 n_0501 n_0502 u_cas_diff_out_diff2_b10 n_0963 VDD VDD VSS VSS
+ gf180mcu_fd_sc_mcu7t5v0__aoi22_1
Xn_1598 n_0503 u_cas_diff_out_diff2_b9 n_0504 u_cas_diff_out_diff2_b8 n_0964 VDD VDD VSS VSS
+ gf180mcu_fd_sc_mcu7t5v0__aoi22_1
Xn_1599 n_0963 n_0964 n_0965 VDD VDD VSS VSS gf180mcu_fd_sc_mcu7t5v0__nand2_1
Xn_1600 n_0501 u_cas_diff_out_diff2_b11 n_0966 VDD VDD VSS VSS gf180mcu_fd_sc_mcu7t5v0__or2_1
Xn_1601 u_cas_diff_out_diff2_b11 n_0501 n_0504 u_cas_diff_out_diff2_b8 n_0967 VDD VDD VSS VSS
+ gf180mcu_fd_sc_mcu7t5v0__oai22_1
Xn_1602 n_0502 u_cas_diff_out_diff2_b10 n_0503 u_cas_diff_out_diff2_b9 n_0968 VDD VDD VSS VSS
+ gf180mcu_fd_sc_mcu7t5v0__oai22_1
Xn_1603 n_0965 n_0967 n_0968 n_0969 VDD VDD VSS VSS gf180mcu_fd_sc_mcu7t5v0__or3_1
Xn_1604 n_0969 n_0970 VDD VDD VSS VSS gf180mcu_fd_sc_mcu7t5v0__clkinv_1
Xn_1605 n_0968 n_0964 n_0963 n_0971 VDD VDD VSS VSS gf180mcu_fd_sc_mcu7t5v0__oai21_1
Xn_1606 n_0971 n_0966 n_0972 VDD VDD VSS VSS gf180mcu_fd_sc_mcu7t5v0__nand2_1
Xn_1607 n_0962 n_0970 n_0971 n_0966 n_0973 VDD VDD VSS VSS gf180mcu_fd_sc_mcu7t5v0__aoi22_1
Xn_1608 n_0944 n_0973 n_0945 n_0974 VDD VDD VSS VSS gf180mcu_fd_sc_mcu7t5v0__oai21_1
Xn_1609 n_0499 u_cas_diff_out_diff2_b13 n_0974 n_0050 VDD VDD VSS VSS
+ gf180mcu_fd_sc_mcu7t5v0__xor3_1
Xn_1610 n_0517 u_cas_diff_u_diff3_in_min1_b14 n_0975 VDD VDD VSS VSS gf180mcu_fd_sc_mcu7t5v0__nor2_1
Xn_1611 u_cas_diff_u_diff3_in_min1_b14 u_cas_diff_out_diff2_b14 n_0976 VDD VDD VSS VSS
+ gf180mcu_fd_sc_mcu7t5v0__xnor2_1
Xn_1612 n_0499 u_cas_diff_out_diff2_b13 n_0500 u_cas_diff_out_diff2_b12 n_0977 VDD VDD VSS VSS
+ gf180mcu_fd_sc_mcu7t5v0__aoi22_1
Xn_1613 n_0977 n_0978 VDD VDD VSS VSS gf180mcu_fd_sc_mcu7t5v0__clkinv_1
Xn_1614 n_0944 n_0942 n_0979 VDD VDD VSS VSS gf180mcu_fd_sc_mcu7t5v0__nand2_1
Xn_1615 n_0944 n_0973 n_0945 n_0942 n_0980 VDD VDD VSS VSS gf180mcu_fd_sc_mcu7t5v0__oai211_1
Xn_1616 n_0943 n_0980 n_0976 n_0981 VDD VDD VSS VSS gf180mcu_fd_sc_mcu7t5v0__aoi21_1
Xn_1617 n_0976 n_0943 n_0982 VDD VDD VSS VSS gf180mcu_fd_sc_mcu7t5v0__and2_1
Xn_1618 n_0980 n_0982 n_0981 n_0051 VDD VDD VSS VSS gf180mcu_fd_sc_mcu7t5v0__aoi21_1
Xn_1619 n_0518 u_cas_diff_u_diff3_in_min1_b15 n_0983 VDD VDD VSS VSS
+ gf180mcu_fd_sc_mcu7t5v0__nand2_1
Xn_1620 u_cas_diff_u_diff3_in_min1_b15 u_cas_diff_out_diff2_b15 n_0984 VDD VDD VSS VSS
+ gf180mcu_fd_sc_mcu7t5v0__xnor2_1
Xn_1621 n_0980 n_0982 n_0975 n_0985 VDD VDD VSS VSS gf180mcu_fd_sc_mcu7t5v0__aoi21_1
Xn_1622 n_0984 n_0985 n_0052 VDD VDD VSS VSS gf180mcu_fd_sc_mcu7t5v0__xnor2_1
Xn_1623 n_0519 u_cas_diff_u_diff3_in_min1_b16 n_0986 VDD VDD VSS VSS gf180mcu_fd_sc_mcu7t5v0__nor2_1
Xn_1624 u_cas_diff_u_diff3_in_min1_b16 u_cas_diff_out_diff2_b16 n_0987 VDD VDD VSS VSS
+ gf180mcu_fd_sc_mcu7t5v0__xnor2_1
Xn_1625 u_cas_diff_u_diff3_in_min1_b14 n_0517 n_0518 u_cas_diff_u_diff3_in_min1_b15 n_0988 VDD VDD
+ VSS VSS gf180mcu_fd_sc_mcu7t5v0__oai22_1
Xn_1626 n_0983 n_0988 n_0989 VDD VDD VSS VSS gf180mcu_fd_sc_mcu7t5v0__nand2_1
Xn_1627 n_0976 n_0984 n_0979 n_0943 n_0990 VDD VDD VSS VSS gf180mcu_fd_sc_mcu7t5v0__nand4_1
Xn_1628 n_0943 n_0978 n_0984 n_0976 n_0991 VDD VDD VSS VSS gf180mcu_fd_sc_mcu7t5v0__nand4_1
Xn_1629 n_0972 n_0989 n_0991 n_0992 VDD VDD VSS VSS gf180mcu_fd_sc_mcu7t5v0__nand3_1
Xn_1630 n_0962 n_0970 n_0992 n_0993 VDD VDD VSS VSS gf180mcu_fd_sc_mcu7t5v0__aoi21_1
Xn_1631 n_0989 n_0990 n_0994 VDD VDD VSS VSS gf180mcu_fd_sc_mcu7t5v0__and2_1
Xn_1632 n_0989 n_0990 n_0993 n_0995 VDD VDD VSS VSS gf180mcu_fd_sc_mcu7t5v0__aoi21_1
Xn_1633 n_0987 n_0995 n_0053 VDD VDD VSS VSS gf180mcu_fd_sc_mcu7t5v0__xor2_1
Xn_1634 n_0995 n_0987 n_0986 n_0996 VDD VDD VSS VSS gf180mcu_fd_sc_mcu7t5v0__aoi21_1
Xn_1635 n_0520 u_cas_diff_u_diff3_in_min1_b17 n_0997 VDD VDD VSS VSS
+ gf180mcu_fd_sc_mcu7t5v0__nand2_1
Xn_1636 n_0520 u_cas_diff_u_diff3_in_min1_b17 n_0998 VDD VDD VSS VSS gf180mcu_fd_sc_mcu7t5v0__or2_1
Xn_1637 u_cas_diff_u_diff3_in_min1_b17 u_cas_diff_out_diff2_b17 n_0996 n_0054 VDD VDD VSS VSS
+ gf180mcu_fd_sc_mcu7t5v0__xor3_1
Xn_1638 u_cas_diff_u_diff3_in_min1_b16 n_0519 n_0520 u_cas_diff_u_diff3_in_min1_b17 n_0999 VDD VDD
+ VSS VSS gf180mcu_fd_sc_mcu7t5v0__oai22_1
Xn_1639 n_0997 n_0999 n_1000 VDD VDD VSS VSS gf180mcu_fd_sc_mcu7t5v0__nand2_1
Xn_1640 n_0987 n_0997 n_0998 n_1001 VDD VDD VSS VSS gf180mcu_fd_sc_mcu7t5v0__nand3_1
Xn_1641 n_0993 n_0994 n_1001 n_1000 n_1002 VDD VDD VSS VSS gf180mcu_fd_sc_mcu7t5v0__oai31_1
Xn_1642 n_0521 u_cas_diff_u_diff3_in_min1_b18 n_1003 VDD VDD VSS VSS gf180mcu_fd_sc_mcu7t5v0__nor2_1
Xn_1643 u_cas_diff_u_diff3_in_min1_b18 n_0521 n_1004 VDD VDD VSS VSS gf180mcu_fd_sc_mcu7t5v0__xor2_1
Xn_1644 u_cas_diff_u_diff3_in_min1_b18 u_cas_diff_out_diff2_b18 n_1005 VDD VDD VSS VSS
+ gf180mcu_fd_sc_mcu7t5v0__xor2_1
Xn_1645 n_1002 n_1004 n_0055 VDD VDD VSS VSS gf180mcu_fd_sc_mcu7t5v0__xor2_1
Xn_1646 n_0522 u_cas_diff_u_diff3_in_min1_b19 n_1006 VDD VDD VSS VSS
+ gf180mcu_fd_sc_mcu7t5v0__nand2_1
Xn_1647 n_0522 u_cas_diff_u_diff3_in_min1_b19 n_1007 VDD VDD VSS VSS gf180mcu_fd_sc_mcu7t5v0__nor2_1
Xn_1648 u_cas_diff_u_diff3_in_min1_b19 u_cas_diff_out_diff2_b19 n_1008 VDD VDD VSS VSS
+ gf180mcu_fd_sc_mcu7t5v0__xor2_1
Xn_1649 n_1002 n_1004 n_1003 n_1009 VDD VDD VSS VSS gf180mcu_fd_sc_mcu7t5v0__aoi21_1
Xn_1650 n_1008 n_1009 n_0056 VDD VDD VSS VSS gf180mcu_fd_sc_mcu7t5v0__xor2_1
Xn_1651 n_1001 n_1005 n_1008 n_1010 VDD VDD VSS VSS gf180mcu_fd_sc_mcu7t5v0__or3_1
Xn_1652 n_1010 n_0994 n_1011 VDD VDD VSS VSS gf180mcu_fd_sc_mcu7t5v0__or2_1
Xn_1653 n_1000 n_1005 n_1008 n_1012 VDD VDD VSS VSS gf180mcu_fd_sc_mcu7t5v0__nor3_1
Xn_1654 n_1006 n_1003 n_1012 n_1007 n_1013 VDD VDD VSS VSS gf180mcu_fd_sc_mcu7t5v0__aoi211_1
Xn_1655 n_0993 n_1011 n_1013 n_1014 VDD VDD VSS VSS gf180mcu_fd_sc_mcu7t5v0__oai21_1
Xn_1656 n_0523 u_cas_diff_u_diff3_in_min1_b20 n_1015 VDD VDD VSS VSS gf180mcu_fd_sc_mcu7t5v0__nor2_1
Xn_1657 u_cas_diff_u_diff3_in_min1_b20 n_0523 n_1016 VDD VDD VSS VSS gf180mcu_fd_sc_mcu7t5v0__xor2_1
Xn_1658 n_1014 n_1016 n_0057 VDD VDD VSS VSS gf180mcu_fd_sc_mcu7t5v0__xor2_1
Xn_1659 n_1014 n_1016 n_1015 n_1017 VDD VDD VSS VSS gf180mcu_fd_sc_mcu7t5v0__aoi21_1
Xn_1660 n_0524 u_cas_diff_out_diff2_b21 n_1018 VDD VDD VSS VSS gf180mcu_fd_sc_mcu7t5v0__nand2_1
Xn_1661 n_0524 u_cas_diff_out_diff2_b21 n_1019 VDD VDD VSS VSS gf180mcu_fd_sc_mcu7t5v0__or2_1
Xn_1662 u_cas_diff_u_diff3_in_min1_b21 u_cas_diff_out_diff2_b21 n_1017 n_0058 VDD VDD VSS VSS
+ gf180mcu_fd_sc_mcu7t5v0__xor3_1
Xn_1663 n_0525 u_cas_diff_out_diff2_b22 n_1020 VDD VDD VSS VSS gf180mcu_fd_sc_mcu7t5v0__nand2_1
Xn_1664 u_cas_diff_u_diff3_in_min1_b22 u_cas_diff_out_diff2_b22 n_1021 VDD VDD VSS VSS
+ gf180mcu_fd_sc_mcu7t5v0__xor2_1
Xn_1665 n_1016 n_1018 n_1019 n_1022 VDD VDD VSS VSS gf180mcu_fd_sc_mcu7t5v0__and3_1
Xn_1666 n_1019 n_1015 n_1023 VDD VDD VSS VSS gf180mcu_fd_sc_mcu7t5v0__nand2_1
Xn_1667 n_1018 n_1023 n_1024 VDD VDD VSS VSS gf180mcu_fd_sc_mcu7t5v0__nand2_1
Xn_1668 n_1014 n_1022 n_1024 n_1025 VDD VDD VSS VSS gf180mcu_fd_sc_mcu7t5v0__aoi21_1
Xn_1669 n_1021 n_1025 n_0059 VDD VDD VSS VSS gf180mcu_fd_sc_mcu7t5v0__xor2_1
Xn_1670 n_0526 u_cas_diff_u_diff3_in_min1_b23 n_1026 VDD VDD VSS VSS gf180mcu_fd_sc_mcu7t5v0__nor2_1
Xn_1671 u_cas_diff_u_diff3_in_min1_b23 n_0526 n_1027 VDD VDD VSS VSS gf180mcu_fd_sc_mcu7t5v0__xor2_1
Xn_1672 u_cas_diff_u_diff3_in_min1_b23 u_cas_diff_out_diff2_b23 n_1028 VDD VDD VSS VSS
+ gf180mcu_fd_sc_mcu7t5v0__xor2_1
Xn_1673 n_1025 n_1021 n_1020 n_1029 VDD VDD VSS VSS gf180mcu_fd_sc_mcu7t5v0__oai21_1
Xn_1674 n_1028 n_1029 n_1030 VDD VDD VSS VSS gf180mcu_fd_sc_mcu7t5v0__nand2_1
Xn_1675 n_1025 n_1021 n_1020 n_1027 n_1031 VDD VDD VSS VSS gf180mcu_fd_sc_mcu7t5v0__oai211_1
Xn_1676 n_1030 n_1031 n_0060 VDD VDD VSS VSS gf180mcu_fd_sc_mcu7t5v0__nand2_1
Xn_1677 n_1021 n_1028 n_1032 VDD VDD VSS VSS gf180mcu_fd_sc_mcu7t5v0__or2_1
Xn_1678 u_cas_diff_u_diff3_in_min1_b23 n_0526 n_1020 n_1033 VDD VDD VSS VSS
+ gf180mcu_fd_sc_mcu7t5v0__aoi21_1
Xn_1679 n_1026 n_1033 n_1034 VDD VDD VSS VSS gf180mcu_fd_sc_mcu7t5v0__nor2_1
Xn_1680 n_1025 n_1032 n_1034 n_0145 VDD VDD VSS VSS gf180mcu_fd_sc_mcu7t5v0__oai21_1
Xn_1681 u_cas_diff_u_diff3_in_min1_b24 u_cas_diff_out_diff2_b24 n_0146 VDD VDD VSS VSS
+ gf180mcu_fd_sc_mcu7t5v0__xor2_1
Xn_1682 u_cas_diff_u_diff3_in_min1_b24 u_cas_diff_out_diff2_b24 n_0147 VDD VDD VSS VSS
+ gf180mcu_fd_sc_mcu7t5v0__xnor2_1
Xn_1683 n_0145 n_0146 n_0148 VDD VDD VSS VSS gf180mcu_fd_sc_mcu7t5v0__nand2_1
Xn_1684 n_1025 n_1032 n_1034 n_0147 n_0149 VDD VDD VSS VSS gf180mcu_fd_sc_mcu7t5v0__oai211_1
Xn_1685 n_0148 n_0149 n_0061 VDD VDD VSS VSS gf180mcu_fd_sc_mcu7t5v0__nand2_1
Xn_1686 n_0527 u_cas_diff_u_diff2_in_min1_b1 n_0150 VDD VDD VSS VSS gf180mcu_fd_sc_mcu7t5v0__nand2_1
Xn_1687 n_0528 u_cas_diff_u_diff2_in_min1_b0 n_0151 VDD VDD VSS VSS gf180mcu_fd_sc_mcu7t5v0__nand2_1
Xn_1688 u_cas_diff_u_diff2_in_min1_b1 n_0527 n_0151 n_0036 VDD VDD VSS VSS
+ gf180mcu_fd_sc_mcu7t5v0__xor3_1
Xn_1689 n_0530 u_cas_diff_u_diff2_in_min1_b2 n_0152 VDD VDD VSS VSS gf180mcu_fd_sc_mcu7t5v0__nor2_1
Xn_1690 n_0529 u_cas_diff_out_diff1_b2 n_0153 VDD VDD VSS VSS gf180mcu_fd_sc_mcu7t5v0__nand2_1
Xn_1691 n_0530 u_cas_diff_u_diff2_in_min1_b2 n_0154 VDD VDD VSS VSS gf180mcu_fd_sc_mcu7t5v0__nand2_1
Xn_1692 n_0527 u_cas_diff_u_diff2_in_min1_b1 n_0528 u_cas_diff_u_diff2_in_min1_b0 n_0155 VDD VDD VSS
+ VSS gf180mcu_fd_sc_mcu7t5v0__oai211_1
Xn_1693 n_0150 n_0155 n_0156 VDD VDD VSS VSS gf180mcu_fd_sc_mcu7t5v0__nand2_1
Xn_1694 n_0150 n_0153 n_0154 n_0155 n_0157 VDD VDD VSS VSS gf180mcu_fd_sc_mcu7t5v0__nand4_1
Xn_1695 u_cas_diff_u_diff2_in_min1_b2 u_cas_diff_out_diff1_b2 n_0156 n_0042 VDD VDD VSS VSS
+ gf180mcu_fd_sc_mcu7t5v0__xor3_1
Xn_1696 n_0153 n_0157 n_0158 VDD VDD VSS VSS gf180mcu_fd_sc_mcu7t5v0__nand2_1
Xn_1697 n_0532 u_cas_diff_u_diff2_in_min1_b3 n_0159 VDD VDD VSS VSS gf180mcu_fd_sc_mcu7t5v0__nor2_1
Xn_1698 n_0531 u_cas_diff_out_diff1_b3 n_0160 VDD VDD VSS VSS gf180mcu_fd_sc_mcu7t5v0__nand2_1
Xn_1699 n_0532 u_cas_diff_u_diff2_in_min1_b3 n_0161 VDD VDD VSS VSS gf180mcu_fd_sc_mcu7t5v0__nand2_1
Xn_1700 u_cas_diff_u_diff2_in_min1_b3 n_0532 n_0158 n_0043 VDD VDD VSS VSS
+ gf180mcu_fd_sc_mcu7t5v0__xor3_1
Xn_1701 n_0534 u_cas_diff_u_diff2_in_min1_b4 n_0162 VDD VDD VSS VSS gf180mcu_fd_sc_mcu7t5v0__nand2_1
Xn_1702 n_0533 u_cas_diff_out_diff1_b4 n_0163 VDD VDD VSS VSS gf180mcu_fd_sc_mcu7t5v0__nand2_1
Xn_1703 n_0152 n_0161 n_0159 n_0164 VDD VDD VSS VSS gf180mcu_fd_sc_mcu7t5v0__aoi21_1
Xn_1704 n_0153 n_0154 n_0160 n_0161 n_0165 VDD VDD VSS VSS gf180mcu_fd_sc_mcu7t5v0__nand4_1
Xn_1705 n_0156 n_0165 n_0164 n_0166 VDD VDD VSS VSS gf180mcu_fd_sc_mcu7t5v0__oai21_1
Xn_1706 n_0166 n_0163 n_0162 n_0167 VDD VDD VSS VSS gf180mcu_fd_sc_mcu7t5v0__nand3_1
Xn_1707 n_0533 u_cas_diff_out_diff1_b4 n_0166 n_0044 VDD VDD VSS VSS gf180mcu_fd_sc_mcu7t5v0__xor3_1
Xn_1708 n_0163 n_0167 n_0168 VDD VDD VSS VSS gf180mcu_fd_sc_mcu7t5v0__nand2_1
Xn_1709 n_0535 u_cas_diff_out_diff1_b5 n_0169 VDD VDD VSS VSS gf180mcu_fd_sc_mcu7t5v0__nand2_1
Xn_1710 n_0536 u_cas_diff_u_diff2_in_min1_b5 n_0170 VDD VDD VSS VSS gf180mcu_fd_sc_mcu7t5v0__nand2_1
Xn_1711 u_cas_diff_u_diff2_in_min1_b5 n_0536 n_0168 n_0045 VDD VDD VSS VSS
+ gf180mcu_fd_sc_mcu7t5v0__xor3_1
Xn_1712 n_0538 u_cas_diff_u_diff2_in_min1_b6 n_0171 VDD VDD VSS VSS gf180mcu_fd_sc_mcu7t5v0__nand2_1
Xn_1713 n_0537 u_cas_diff_out_diff1_b6 n_0172 VDD VDD VSS VSS gf180mcu_fd_sc_mcu7t5v0__nand2_1
Xn_1714 n_0172 n_0173 VDD VDD VSS VSS gf180mcu_fd_sc_mcu7t5v0__clkinv_1
Xn_1715 n_0171 n_0172 n_0174 VDD VDD VSS VSS gf180mcu_fd_sc_mcu7t5v0__nand2_1
Xn_1716 n_0533 u_cas_diff_out_diff1_b4 n_0535 u_cas_diff_out_diff1_b5 n_0175 VDD VDD VSS VSS
+ gf180mcu_fd_sc_mcu7t5v0__aoi22_1
Xn_1717 u_cas_diff_u_diff2_in_min1_b4 n_0534 n_0536 u_cas_diff_u_diff2_in_min1_b5 n_0176 VDD VDD VSS
+ VSS gf180mcu_fd_sc_mcu7t5v0__oai22_1
Xn_1718 u_cas_diff_u_diff2_in_min1_b5 n_0536 n_0175 n_0177 VDD VDD VSS VSS
+ gf180mcu_fd_sc_mcu7t5v0__aoi21_1
Xn_1719 n_0170 n_0176 n_0178 VDD VDD VSS VSS gf180mcu_fd_sc_mcu7t5v0__nand2_1
Xn_1720 n_0162 n_0163 n_0169 n_0170 n_0179 VDD VDD VSS VSS gf180mcu_fd_sc_mcu7t5v0__nand4_1
Xn_1721 n_0167 n_0175 u_cas_diff_u_diff2_in_min1_b5 n_0536 n_0180 VDD VDD VSS VSS
+ gf180mcu_fd_sc_mcu7t5v0__aoi22_1
Xn_1722 n_0174 n_0180 n_0046 VDD VDD VSS VSS gf180mcu_fd_sc_mcu7t5v0__xnor2_1
Xn_1723 n_0180 n_0171 n_0173 n_0181 VDD VDD VSS VSS gf180mcu_fd_sc_mcu7t5v0__aoi21_1
Xn_1724 n_0539 u_cas_diff_out_diff1_b7 n_0182 VDD VDD VSS VSS gf180mcu_fd_sc_mcu7t5v0__nand2_1
Xn_1725 n_0539 u_cas_diff_out_diff1_b7 n_0183 VDD VDD VSS VSS gf180mcu_fd_sc_mcu7t5v0__nor2_1
Xn_1726 n_0540 u_cas_diff_u_diff2_in_min1_b7 n_0184 VDD VDD VSS VSS gf180mcu_fd_sc_mcu7t5v0__nand2_1
Xn_1727 u_cas_diff_u_diff2_in_min1_b7 u_cas_diff_out_diff1_b7 n_0181 n_0047 VDD VDD VSS VSS
+ gf180mcu_fd_sc_mcu7t5v0__xor3_1
Xn_1728 n_0171 n_0172 n_0182 n_0184 n_0185 VDD VDD VSS VSS gf180mcu_fd_sc_mcu7t5v0__and4_1
Xn_1729 n_0171 n_0172 n_0182 n_0184 n_0186 VDD VDD VSS VSS gf180mcu_fd_sc_mcu7t5v0__nand4_1
Xn_1730 n_0179 n_0186 n_0187 VDD VDD VSS VSS gf180mcu_fd_sc_mcu7t5v0__nor2_1
Xn_1731 n_0166 n_0187 n_0188 VDD VDD VSS VSS gf180mcu_fd_sc_mcu7t5v0__nand2_1
Xn_1732 n_0183 n_0172 n_0182 n_0189 VDD VDD VSS VSS gf180mcu_fd_sc_mcu7t5v0__oai21_1
Xn_1733 n_0177 n_0185 n_0189 n_0190 VDD VDD VSS VSS gf180mcu_fd_sc_mcu7t5v0__aoi21_1
Xn_1734 n_0178 n_0186 n_0183 n_0172 n_0182 n_0191 VDD VDD VSS VSS gf180mcu_fd_sc_mcu7t5v0__oai221_1
Xn_1735 n_0166 n_0187 n_0191 n_0192 VDD VDD VSS VSS gf180mcu_fd_sc_mcu7t5v0__aoi21_1
Xn_1736 n_0188 n_0190 n_0193 VDD VDD VSS VSS gf180mcu_fd_sc_mcu7t5v0__nand2_1
Xn_1737 n_0541 u_cas_diff_out_diff1_b8 n_0194 VDD VDD VSS VSS gf180mcu_fd_sc_mcu7t5v0__or2_1
Xn_1738 n_0541 u_cas_diff_out_diff1_b8 n_0195 VDD VDD VSS VSS gf180mcu_fd_sc_mcu7t5v0__nand2_1
Xn_1739 n_0194 n_0195 n_0196 VDD VDD VSS VSS gf180mcu_fd_sc_mcu7t5v0__nand2_1
Xn_1740 n_0192 n_0196 n_0048 VDD VDD VSS VSS gf180mcu_fd_sc_mcu7t5v0__xor2_1
Xn_1741 n_0543 u_cas_diff_u_diff2_in_min1_b9 n_0197 VDD VDD VSS VSS gf180mcu_fd_sc_mcu7t5v0__nand2_1
Xn_1742 n_0542 u_cas_diff_out_diff1_b9 n_0198 VDD VDD VSS VSS gf180mcu_fd_sc_mcu7t5v0__nand2_1
Xn_1743 n_0192 n_0196 n_0195 n_0199 VDD VDD VSS VSS gf180mcu_fd_sc_mcu7t5v0__oai21_1
Xn_1744 u_cas_diff_u_diff2_in_min1_b9 n_0543 n_0199 n_0049 VDD VDD VSS VSS
+ gf180mcu_fd_sc_mcu7t5v0__xor3_1
Xn_1745 n_0194 n_0195 n_0197 n_0198 n_0200 VDD VDD VSS VSS gf180mcu_fd_sc_mcu7t5v0__and4_1
Xn_1746 n_0542 u_cas_diff_out_diff1_b9 n_0541 u_cas_diff_out_diff1_b8 n_0201 VDD VDD VSS VSS
+ gf180mcu_fd_sc_mcu7t5v0__oai211_1
Xn_1747 n_0198 n_0201 n_0202 VDD VDD VSS VSS gf180mcu_fd_sc_mcu7t5v0__nand2_1
Xn_1748 n_0198 n_0201 n_0203 VDD VDD VSS VSS gf180mcu_fd_sc_mcu7t5v0__and2_1
Xn_1749 n_0193 n_0200 n_0202 n_0204 VDD VDD VSS VSS gf180mcu_fd_sc_mcu7t5v0__aoi21_1
Xn_1750 n_0545 u_cas_diff_u_diff2_in_min1_b10 n_0205 VDD VDD VSS VSS
+ gf180mcu_fd_sc_mcu7t5v0__nand2_1
Xn_1751 n_0544 u_cas_diff_out_diff1_b10 n_0206 VDD VDD VSS VSS gf180mcu_fd_sc_mcu7t5v0__nand2_1
Xn_1752 n_0205 n_0206 n_0207 VDD VDD VSS VSS gf180mcu_fd_sc_mcu7t5v0__nand2_1
Xn_1753 n_0204 n_0207 n_0026 VDD VDD VSS VSS gf180mcu_fd_sc_mcu7t5v0__xor2_1
Xn_1754 n_0204 n_0207 n_0206 n_0208 VDD VDD VSS VSS gf180mcu_fd_sc_mcu7t5v0__oai21_1
Xn_1755 n_0546 u_cas_diff_out_diff1_b11 n_0209 VDD VDD VSS VSS gf180mcu_fd_sc_mcu7t5v0__nor2_1
Xn_1756 n_0547 u_cas_diff_u_diff2_in_min1_b11 n_0210 VDD VDD VSS VSS
+ gf180mcu_fd_sc_mcu7t5v0__nand2_1
Xn_1757 n_0546 u_cas_diff_out_diff1_b11 n_0211 VDD VDD VSS VSS gf180mcu_fd_sc_mcu7t5v0__nand2_1
Xn_1758 u_cas_diff_u_diff2_in_min1_b11 n_0547 n_0208 n_0027 VDD VDD VSS VSS
+ gf180mcu_fd_sc_mcu7t5v0__xor3_1
Xn_1759 n_0549 u_cas_diff_u_diff2_in_min1_b12 n_0212 VDD VDD VSS VSS
+ gf180mcu_fd_sc_mcu7t5v0__nand2_1
Xn_1760 n_0548 u_cas_diff_out_diff1_b12 n_0213 VDD VDD VSS VSS gf180mcu_fd_sc_mcu7t5v0__nand2_1
Xn_1761 n_0212 n_0213 n_0214 VDD VDD VSS VSS gf180mcu_fd_sc_mcu7t5v0__and2_1
Xn_1762 n_0205 n_0206 n_0210 n_0211 n_0215 VDD VDD VSS VSS gf180mcu_fd_sc_mcu7t5v0__and4_1
Xn_1763 n_0205 n_0206 n_0210 n_0211 n_0216 VDD VDD VSS VSS gf180mcu_fd_sc_mcu7t5v0__nand4_1
Xn_1764 n_0544 n_0210 u_cas_diff_out_diff1_b10 n_0217 VDD VDD VSS VSS
+ gf180mcu_fd_sc_mcu7t5v0__nand3_1
Xn_1765 n_0209 n_0206 n_0211 n_0218 VDD VDD VSS VSS gf180mcu_fd_sc_mcu7t5v0__oai21_1
Xn_1766 n_0202 n_0215 n_0218 n_0219 VDD VDD VSS VSS gf180mcu_fd_sc_mcu7t5v0__aoi21_1
Xn_1767 n_0203 n_0216 n_0217 n_0211 n_0220 VDD VDD VSS VSS gf180mcu_fd_sc_mcu7t5v0__oai211_1
Xn_1768 n_0200 n_0215 n_0221 VDD VDD VSS VSS gf180mcu_fd_sc_mcu7t5v0__nand2_1
Xn_1769 n_0192 n_0221 n_0219 n_0222 VDD VDD VSS VSS gf180mcu_fd_sc_mcu7t5v0__oai21_1
Xn_1770 n_0212 n_0213 n_0222 n_0223 VDD VDD VSS VSS gf180mcu_fd_sc_mcu7t5v0__nand3_1
Xn_1771 n_0214 n_0222 n_0028 VDD VDD VSS VSS gf180mcu_fd_sc_mcu7t5v0__xor2_1
Xn_1772 n_0551 u_cas_diff_u_diff2_in_min1_b13 n_0224 VDD VDD VSS VSS
+ gf180mcu_fd_sc_mcu7t5v0__nand2_1
Xn_1773 n_0550 u_cas_diff_out_diff1_b13 n_0225 VDD VDD VSS VSS gf180mcu_fd_sc_mcu7t5v0__nand2_1
Xn_1774 n_0224 n_0225 n_0226 VDD VDD VSS VSS gf180mcu_fd_sc_mcu7t5v0__and2_1
Xn_1775 n_0213 n_0223 n_0227 VDD VDD VSS VSS gf180mcu_fd_sc_mcu7t5v0__nand2_1
Xn_1776 n_0226 n_0227 n_0029 VDD VDD VSS VSS gf180mcu_fd_sc_mcu7t5v0__xor2_1
Xn_1777 n_0222 n_0226 n_0214 n_0228 VDD VDD VSS VSS gf180mcu_fd_sc_mcu7t5v0__nand3_1
Xn_1778 n_0213 n_0225 n_0229 VDD VDD VSS VSS gf180mcu_fd_sc_mcu7t5v0__nand2_1
Xn_1779 n_0224 n_0229 n_0230 VDD VDD VSS VSS gf180mcu_fd_sc_mcu7t5v0__nand2_1
Xn_1780 n_0228 n_0230 n_0231 VDD VDD VSS VSS gf180mcu_fd_sc_mcu7t5v0__and2_1
Xn_1781 n_0552 u_cas_diff_out_diff1_b14 n_0232 VDD VDD VSS VSS gf180mcu_fd_sc_mcu7t5v0__nor2_1
Xn_1782 n_0553 u_cas_diff_u_diff2_in_min1_b14 n_0233 VDD VDD VSS VSS
+ gf180mcu_fd_sc_mcu7t5v0__nand2_1
Xn_1783 n_0553 u_cas_diff_u_diff2_in_min1_b14 n_0234 VDD VDD VSS VSS gf180mcu_fd_sc_mcu7t5v0__nor2_1
Xn_1784 n_0552 u_cas_diff_out_diff1_b14 n_0235 VDD VDD VSS VSS gf180mcu_fd_sc_mcu7t5v0__nand2_1
Xn_1785 n_0228 n_0230 n_0232 n_0234 n_0236 VDD VDD VSS VSS gf180mcu_fd_sc_mcu7t5v0__aoi211_1
Xn_1786 u_cas_diff_u_diff2_in_min1_b14 u_cas_diff_out_diff1_b14 n_0231 n_0030 VDD VDD VSS VSS
+ gf180mcu_fd_sc_mcu7t5v0__xor3_1
Xn_1787 n_0555 u_cas_diff_u_diff2_in_min1_b15 n_0237 VDD VDD VSS VSS gf180mcu_fd_sc_mcu7t5v0__nor2_1
Xn_1788 n_0554 u_cas_diff_out_diff1_b15 n_0238 VDD VDD VSS VSS gf180mcu_fd_sc_mcu7t5v0__nand2_1
Xn_1789 n_0554 u_cas_diff_out_diff1_b15 n_0239 VDD VDD VSS VSS gf180mcu_fd_sc_mcu7t5v0__nor2_1
Xn_1790 n_0555 u_cas_diff_u_diff2_in_min1_b15 n_0240 VDD VDD VSS VSS
+ gf180mcu_fd_sc_mcu7t5v0__nand2_1
Xn_1791 n_0237 n_0239 n_0241 VDD VDD VSS VSS gf180mcu_fd_sc_mcu7t5v0__nor2_1
Xn_1792 n_0234 n_0236 n_0237 n_0239 n_0242 VDD VDD VSS VSS gf180mcu_fd_sc_mcu7t5v0__oai22_1
Xn_1793 n_0231 n_0232 n_0235 n_0241 n_0243 VDD VDD VSS VSS gf180mcu_fd_sc_mcu7t5v0__oai211_1
Xn_1794 n_0242 n_0243 n_0031 VDD VDD VSS VSS gf180mcu_fd_sc_mcu7t5v0__nand2_1
Xn_1795 n_0556 u_cas_diff_u_diff2_in_min1_b16 n_0244 VDD VDD VSS VSS
+ gf180mcu_fd_sc_mcu7t5v0__nand2_1
Xn_1796 n_0556 u_cas_diff_u_diff2_in_min1_b16 n_0245 VDD VDD VSS VSS gf180mcu_fd_sc_mcu7t5v0__nor2_1
Xn_1797 u_cas_diff_u_diff2_in_min1_b16 u_cas_diff_out_diff1_b16 n_0246 VDD VDD VSS VSS
+ gf180mcu_fd_sc_mcu7t5v0__xor2_1
Xn_1798 n_0233 n_0235 n_0238 n_0240 n_0247 VDD VDD VSS VSS gf180mcu_fd_sc_mcu7t5v0__and4_1
Xn_1799 n_0233 n_0235 n_0238 n_0240 n_0248 VDD VDD VSS VSS gf180mcu_fd_sc_mcu7t5v0__nand4_1
Xn_1800 n_0212 n_0213 n_0224 n_0225 n_0249 VDD VDD VSS VSS gf180mcu_fd_sc_mcu7t5v0__and4_1
Xn_1801 n_0247 n_0213 n_0212 n_0226 n_0250 VDD VDD VSS VSS gf180mcu_fd_sc_mcu7t5v0__and4_1
Xn_1802 n_0247 n_0213 n_0212 n_0226 n_0251 VDD VDD VSS VSS gf180mcu_fd_sc_mcu7t5v0__nand4_1
Xn_1803 n_0200 n_0215 n_0247 n_0249 n_0252 VDD VDD VSS VSS gf180mcu_fd_sc_mcu7t5v0__nand4_1
Xn_1804 n_0188 n_0190 n_0252 n_0253 VDD VDD VSS VSS gf180mcu_fd_sc_mcu7t5v0__aoi21_1
Xn_1805 n_0234 n_0240 n_0237 n_0254 VDD VDD VSS VSS gf180mcu_fd_sc_mcu7t5v0__aoi21_1
Xn_1806 n_0230 n_0248 n_0254 n_0255 VDD VDD VSS VSS gf180mcu_fd_sc_mcu7t5v0__oai21_1
Xn_1807 n_0250 n_0220 n_0255 n_0256 VDD VDD VSS VSS gf180mcu_fd_sc_mcu7t5v0__aoi21_1
Xn_1808 n_0219 n_0251 n_0248 n_0230 n_0254 n_0257 VDD VDD VSS VSS gf180mcu_fd_sc_mcu7t5v0__oai221_1
Xn_1809 n_0253 n_0257 n_0258 VDD VDD VSS VSS gf180mcu_fd_sc_mcu7t5v0__nor2_1
Xn_1810 n_0192 n_0252 n_0256 n_0259 VDD VDD VSS VSS gf180mcu_fd_sc_mcu7t5v0__oai21_1
Xn_1811 n_0246 n_0258 n_0032 VDD VDD VSS VSS gf180mcu_fd_sc_mcu7t5v0__xor2_1
Xn_1812 n_0558 u_cas_diff_u_diff2_in_min1_b17 n_0260 VDD VDD VSS VSS gf180mcu_fd_sc_mcu7t5v0__nor2_1
Xn_1813 n_0557 u_cas_diff_out_diff1_b17 n_0261 VDD VDD VSS VSS gf180mcu_fd_sc_mcu7t5v0__nand2_1
Xn_1814 n_0557 u_cas_diff_out_diff1_b17 n_0262 VDD VDD VSS VSS gf180mcu_fd_sc_mcu7t5v0__nor2_1
Xn_1815 n_0558 u_cas_diff_u_diff2_in_min1_b17 n_0263 VDD VDD VSS VSS
+ gf180mcu_fd_sc_mcu7t5v0__nand2_1
Xn_1816 n_0244 n_0259 n_0245 n_0264 VDD VDD VSS VSS gf180mcu_fd_sc_mcu7t5v0__aoi21_1
Xn_1817 u_cas_diff_u_diff2_in_min1_b17 u_cas_diff_out_diff1_b17 n_0264 n_0033 VDD VDD VSS VSS
+ gf180mcu_fd_sc_mcu7t5v0__xor3_1
Xn_1818 n_0246 n_0260 n_0262 n_0265 VDD VDD VSS VSS gf180mcu_fd_sc_mcu7t5v0__or3_1
Xn_1819 u_cas_diff_u_diff2_in_min1_b16 n_0262 n_0556 n_0261 n_0266 VDD VDD VSS VSS
+ gf180mcu_fd_sc_mcu7t5v0__oai31_1
Xn_1820 n_0245 n_0263 n_0260 n_0267 VDD VDD VSS VSS gf180mcu_fd_sc_mcu7t5v0__aoi21_1
Xn_1821 n_0258 n_0265 n_0267 n_0268 VDD VDD VSS VSS gf180mcu_fd_sc_mcu7t5v0__oai21_1
Xn_1822 n_0559 u_cas_diff_u_diff2_in_min1_b18 n_0269 VDD VDD VSS VSS
+ gf180mcu_fd_sc_mcu7t5v0__nand2_1
Xn_1823 n_0559 u_cas_diff_u_diff2_in_min1_b18 n_0270 VDD VDD VSS VSS gf180mcu_fd_sc_mcu7t5v0__nor2_1
Xn_1824 u_cas_diff_u_diff2_in_min1_b18 u_cas_diff_out_diff1_b18 n_0271 VDD VDD VSS VSS
+ gf180mcu_fd_sc_mcu7t5v0__xor2_1
Xn_1825 n_0268 n_0271 n_0034 VDD VDD VSS VSS gf180mcu_fd_sc_mcu7t5v0__xnor2_1
Xn_1826 n_0268 n_0269 n_0270 n_0272 VDD VDD VSS VSS gf180mcu_fd_sc_mcu7t5v0__aoi21_1
Xn_1827 n_0560 u_cas_diff_u_diff2_in_min1_b19 n_0273 VDD VDD VSS VSS
+ gf180mcu_fd_sc_mcu7t5v0__nand2_1
Xn_1828 n_0560 u_cas_diff_u_diff2_in_min1_b19 n_0274 VDD VDD VSS VSS gf180mcu_fd_sc_mcu7t5v0__nor2_1
Xn_1829 u_cas_diff_u_diff2_in_min1_b19 u_cas_diff_out_diff1_b19 n_0275 VDD VDD VSS VSS
+ gf180mcu_fd_sc_mcu7t5v0__xor2_1
Xn_1830 n_0272 n_0275 n_0035 VDD VDD VSS VSS gf180mcu_fd_sc_mcu7t5v0__xor2_1
Xn_1831 n_0561 u_cas_diff_u_diff2_in_min1_b20 n_0276 VDD VDD VSS VSS gf180mcu_fd_sc_mcu7t5v0__nor2_1
Xn_1832 u_cas_diff_u_diff2_in_min1_b20 n_0561 n_0277 VDD VDD VSS VSS gf180mcu_fd_sc_mcu7t5v0__xor2_1
Xn_1833 n_0271 n_0275 n_0278 VDD VDD VSS VSS gf180mcu_fd_sc_mcu7t5v0__nor2_1
Xn_1834 n_0266 n_0278 n_0273 n_0270 n_0274 n_0279 VDD VDD VSS VSS gf180mcu_fd_sc_mcu7t5v0__aoi221_1
Xn_1835 n_0279 n_0280 VDD VDD VSS VSS gf180mcu_fd_sc_mcu7t5v0__clkinv_1
Xn_1836 n_0265 n_0271 n_0275 n_0281 VDD VDD VSS VSS gf180mcu_fd_sc_mcu7t5v0__nor3_1
Xn_1837 n_0253 n_0257 n_0281 n_0282 VDD VDD VSS VSS gf180mcu_fd_sc_mcu7t5v0__oai21_1
Xn_1838 n_0282 n_0279 n_0283 VDD VDD VSS VSS gf180mcu_fd_sc_mcu7t5v0__nand2_1
Xn_1839 n_0259 n_0281 n_0280 n_0284 VDD VDD VSS VSS gf180mcu_fd_sc_mcu7t5v0__aoi21_1
Xn_1840 n_0277 n_0283 n_0037 VDD VDD VSS VSS gf180mcu_fd_sc_mcu7t5v0__xor2_1
Xn_1841 n_0277 n_0283 n_0276 n_0285 VDD VDD VSS VSS gf180mcu_fd_sc_mcu7t5v0__aoi21_1
Xn_1842 n_0562 u_cas_diff_out_diff1_b21 n_0286 VDD VDD VSS VSS gf180mcu_fd_sc_mcu7t5v0__or2_1
Xn_1843 n_0562 u_cas_diff_out_diff1_b21 n_0287 VDD VDD VSS VSS gf180mcu_fd_sc_mcu7t5v0__nand2_1
Xn_1844 u_cas_diff_u_diff2_in_min1_b21 u_cas_diff_out_diff1_b21 n_0285 n_0038 VDD VDD VSS VSS
+ gf180mcu_fd_sc_mcu7t5v0__xor3_1
Xn_1845 n_0564 u_cas_diff_u_diff2_in_min1_b22 n_0288 VDD VDD VSS VSS gf180mcu_fd_sc_mcu7t5v0__nor2_1
Xn_1846 n_0563 u_cas_diff_out_diff1_b22 n_0289 VDD VDD VSS VSS gf180mcu_fd_sc_mcu7t5v0__nand2_1
Xn_1847 n_0563 u_cas_diff_out_diff1_b22 n_0290 VDD VDD VSS VSS gf180mcu_fd_sc_mcu7t5v0__nor2_1
Xn_1848 n_0288 n_0290 n_0291 VDD VDD VSS VSS gf180mcu_fd_sc_mcu7t5v0__nor2_1
Xn_1849 n_0277 n_0286 n_0287 n_0292 VDD VDD VSS VSS gf180mcu_fd_sc_mcu7t5v0__nand3_1
Xn_1850 n_0282 n_0279 n_0292 n_0293 VDD VDD VSS VSS gf180mcu_fd_sc_mcu7t5v0__aoi21_1
Xn_1851 n_0286 n_0276 n_0294 VDD VDD VSS VSS gf180mcu_fd_sc_mcu7t5v0__nand2_1
Xn_1852 n_0287 n_0294 n_0295 VDD VDD VSS VSS gf180mcu_fd_sc_mcu7t5v0__nand2_1
Xn_1853 n_0295 n_0296 VDD VDD VSS VSS gf180mcu_fd_sc_mcu7t5v0__clkinv_1
Xn_1854 n_0284 n_0292 n_0296 n_0297 VDD VDD VSS VSS gf180mcu_fd_sc_mcu7t5v0__oai21_1
Xn_1855 n_0293 n_0295 n_0291 n_0298 VDD VDD VSS VSS gf180mcu_fd_sc_mcu7t5v0__oai21_1
Xn_1856 n_0291 n_0297 n_0039 VDD VDD VSS VSS gf180mcu_fd_sc_mcu7t5v0__xor2_1
Xn_1857 u_cas_diff_u_diff2_in_min1_b23 n_0566 n_0299 VDD VDD VSS VSS gf180mcu_fd_sc_mcu7t5v0__xor2_1
Xn_1858 u_cas_diff_u_diff2_in_min1_b23 u_cas_diff_out_diff1_b23 n_0300 VDD VDD VSS VSS
+ gf180mcu_fd_sc_mcu7t5v0__xor2_1
Xn_1859 n_0297 n_0291 n_0288 n_0299 n_0301 VDD VDD VSS VSS gf180mcu_fd_sc_mcu7t5v0__aoi211_1
Xn_1860 n_0289 n_0298 n_0300 n_0302 VDD VDD VSS VSS gf180mcu_fd_sc_mcu7t5v0__aoi21_1
Xn_1861 n_0301 n_0302 n_0040 VDD VDD VSS VSS gf180mcu_fd_sc_mcu7t5v0__nor2_1
Xn_1862 n_0300 n_0290 n_0288 n_0303 VDD VDD VSS VSS gf180mcu_fd_sc_mcu7t5v0__nor3_1
Xn_1863 n_0293 n_0295 n_0303 n_0304 VDD VDD VSS VSS gf180mcu_fd_sc_mcu7t5v0__oai21_1
Xn_1864 u_cas_diff_u_diff2_in_min1_b23 n_0566 n_0564 u_cas_diff_u_diff2_in_min1_b22 n_0305 VDD VDD
+ VSS VSS gf180mcu_fd_sc_mcu7t5v0__aoi211_1
Xn_1865 n_0565 u_cas_diff_out_diff1_b23 n_0563 u_cas_diff_out_diff1_b22 n_0306 VDD VDD VSS VSS
+ gf180mcu_fd_sc_mcu7t5v0__oai211_1
Xn_1866 n_0565 u_cas_diff_out_diff1_b23 n_0305 n_0307 VDD VDD VSS VSS
+ gf180mcu_fd_sc_mcu7t5v0__aoi21_1
Xn_1867 u_cas_diff_u_diff2_in_min1_b23 n_0566 n_0306 n_0308 VDD VDD VSS VSS
+ gf180mcu_fd_sc_mcu7t5v0__oai21_1
Xn_1868 u_cas_diff_u_diff2_in_min1_b24 u_cas_diff_out_diff1_b24 n_0309 VDD VDD VSS VSS
+ gf180mcu_fd_sc_mcu7t5v0__xor2_1
Xn_1869 u_cas_diff_u_diff2_in_min1_b24 u_cas_diff_out_diff1_b24 n_0310 VDD VDD VSS VSS
+ gf180mcu_fd_sc_mcu7t5v0__xnor2_1
Xn_1870 n_0304 n_0307 n_0309 n_0311 VDD VDD VSS VSS gf180mcu_fd_sc_mcu7t5v0__aoi21_1
Xn_1871 n_0297 n_0303 n_0308 n_0310 n_0312 VDD VDD VSS VSS gf180mcu_fd_sc_mcu7t5v0__aoi211_1
Xn_1872 n_0311 n_0312 n_0041 VDD VDD VSS VSS gf180mcu_fd_sc_mcu7t5v0__nor2_1
Xn_1873 n_0478 u_cas_diff_u_diff1_in_min1_b1 n_0313 VDD VDD VSS VSS gf180mcu_fd_sc_mcu7t5v0__nand2_1
Xn_1874 n_0479 u_cas_diff_u_diff1_in_min1_b0 n_0314 VDD VDD VSS VSS gf180mcu_fd_sc_mcu7t5v0__nand2_1
Xn_1875 n_0478 u_cas_diff_u_diff1_in_min1_b1 n_0314 n_0011 VDD VDD VSS VSS
+ gf180mcu_fd_sc_mcu7t5v0__xor3_1
Xn_1876 n_0480 u_cas_diff_u_diff1_in_min1_b2 n_0315 VDD VDD VSS VSS gf180mcu_fd_sc_mcu7t5v0__nor2_1
Xn_1877 n_0567 out_cas_int_b2 n_0316 VDD VDD VSS VSS gf180mcu_fd_sc_mcu7t5v0__nand2_1
Xn_1878 n_0480 u_cas_diff_u_diff1_in_min1_b2 n_0317 VDD VDD VSS VSS gf180mcu_fd_sc_mcu7t5v0__nand2_1
Xn_1879 n_0478 u_cas_diff_u_diff1_in_min1_b1 n_0479 u_cas_diff_u_diff1_in_min1_b0 n_0318 VDD VDD VSS
+ VSS gf180mcu_fd_sc_mcu7t5v0__oai211_1
Xn_1880 n_0313 n_0318 n_0319 VDD VDD VSS VSS gf180mcu_fd_sc_mcu7t5v0__nand2_1
Xn_1881 n_0313 n_0316 n_0317 n_0318 n_0320 VDD VDD VSS VSS gf180mcu_fd_sc_mcu7t5v0__nand4_1
Xn_1882 out_cas_int_b2 u_cas_diff_u_diff1_in_min1_b2 n_0319 n_0017 VDD VDD VSS VSS
+ gf180mcu_fd_sc_mcu7t5v0__xor3_1
Xn_1883 n_0316 n_0320 n_0321 VDD VDD VSS VSS gf180mcu_fd_sc_mcu7t5v0__nand2_1
Xn_1884 n_0481 u_cas_diff_u_diff1_in_min1_b3 n_0322 VDD VDD VSS VSS gf180mcu_fd_sc_mcu7t5v0__nor2_1
Xn_1885 n_0568 out_cas_int_b3 n_0323 VDD VDD VSS VSS gf180mcu_fd_sc_mcu7t5v0__nand2_1
Xn_1886 n_0481 u_cas_diff_u_diff1_in_min1_b3 n_0324 VDD VDD VSS VSS gf180mcu_fd_sc_mcu7t5v0__nand2_1
Xn_1887 out_cas_int_b3 n_0568 n_0321 n_0018 VDD VDD VSS VSS gf180mcu_fd_sc_mcu7t5v0__xor3_1
Xn_1888 n_0482 u_cas_diff_u_diff1_in_min1_b4 n_0325 VDD VDD VSS VSS gf180mcu_fd_sc_mcu7t5v0__nor2_1
Xn_1889 n_0569 out_cas_int_b4 n_0326 VDD VDD VSS VSS gf180mcu_fd_sc_mcu7t5v0__nand2_1
Xn_1890 n_0482 u_cas_diff_u_diff1_in_min1_b4 n_0327 VDD VDD VSS VSS gf180mcu_fd_sc_mcu7t5v0__nand2_1
Xn_1891 n_0315 n_0324 n_0322 n_0328 VDD VDD VSS VSS gf180mcu_fd_sc_mcu7t5v0__aoi21_1
Xn_1892 n_0316 n_0317 n_0323 n_0324 n_0329 VDD VDD VSS VSS gf180mcu_fd_sc_mcu7t5v0__nand4_1
Xn_1893 n_0319 n_0329 n_0328 n_0330 VDD VDD VSS VSS gf180mcu_fd_sc_mcu7t5v0__oai21_1
Xn_1894 n_0330 n_0327 n_0326 n_0331 VDD VDD VSS VSS gf180mcu_fd_sc_mcu7t5v0__nand3_1
Xn_1895 n_0482 u_cas_diff_u_diff1_in_min1_b4 n_0330 n_0019 VDD VDD VSS VSS
+ gf180mcu_fd_sc_mcu7t5v0__xor3_1
Xn_1896 n_0326 n_0331 n_0332 VDD VDD VSS VSS gf180mcu_fd_sc_mcu7t5v0__nand2_1
Xn_1897 n_0570 out_cas_int_b5 n_0333 VDD VDD VSS VSS gf180mcu_fd_sc_mcu7t5v0__nor2_1
Xn_1898 n_0483 u_cas_diff_u_diff1_in_min1_b5 n_0334 VDD VDD VSS VSS gf180mcu_fd_sc_mcu7t5v0__nand2_1
Xn_1899 n_0483 u_cas_diff_u_diff1_in_min1_b5 n_0335 VDD VDD VSS VSS gf180mcu_fd_sc_mcu7t5v0__nor2_1
Xn_1900 n_0570 out_cas_int_b5 n_0336 VDD VDD VSS VSS gf180mcu_fd_sc_mcu7t5v0__nand2_1
Xn_1901 out_cas_int_b5 n_0570 n_0332 n_0020 VDD VDD VSS VSS gf180mcu_fd_sc_mcu7t5v0__xor3_1
Xn_1902 n_0571 out_cas_int_b6 n_0337 VDD VDD VSS VSS gf180mcu_fd_sc_mcu7t5v0__nand2_1
Xn_1903 n_0337 n_0338 VDD VDD VSS VSS gf180mcu_fd_sc_mcu7t5v0__clkinv_1
Xn_1904 n_0484 u_cas_diff_u_diff1_in_min1_b6 n_0339 VDD VDD VSS VSS gf180mcu_fd_sc_mcu7t5v0__nand2_1
Xn_1905 n_0337 n_0339 n_0340 VDD VDD VSS VSS gf180mcu_fd_sc_mcu7t5v0__nand2_1
Xn_1906 n_0333 n_0326 n_0336 n_0341 VDD VDD VSS VSS gf180mcu_fd_sc_mcu7t5v0__oai21_1
Xn_1907 n_0325 n_0334 n_0335 n_0342 VDD VDD VSS VSS gf180mcu_fd_sc_mcu7t5v0__aoi21_1
Xn_1908 n_0326 n_0327 n_0334 n_0336 n_0343 VDD VDD VSS VSS gf180mcu_fd_sc_mcu7t5v0__nand4_1
Xn_1909 n_0331 n_0333 n_0335 n_0342 n_0344 VDD VDD VSS VSS gf180mcu_fd_sc_mcu7t5v0__oai31_1
Xn_1910 n_0340 n_0344 n_0021 VDD VDD VSS VSS gf180mcu_fd_sc_mcu7t5v0__xnor2_1
Xn_1911 n_0344 n_0339 n_0338 n_0345 VDD VDD VSS VSS gf180mcu_fd_sc_mcu7t5v0__aoi21_1
Xn_1912 n_0572 out_cas_int_b7 n_0346 VDD VDD VSS VSS gf180mcu_fd_sc_mcu7t5v0__nand2_1
Xn_1913 n_0485 u_cas_diff_u_diff1_in_min1_b7 n_0347 VDD VDD VSS VSS gf180mcu_fd_sc_mcu7t5v0__nand2_1
Xn_1914 out_cas_int_b7 u_cas_diff_u_diff1_in_min1_b7 n_0345 n_0022 VDD VDD VSS VSS
+ gf180mcu_fd_sc_mcu7t5v0__xor3_1
Xn_1915 n_0337 n_0339 n_0346 n_0347 n_0348 VDD VDD VSS VSS gf180mcu_fd_sc_mcu7t5v0__and4_1
Xn_1916 n_0337 n_0339 n_0346 n_0347 n_0349 VDD VDD VSS VSS gf180mcu_fd_sc_mcu7t5v0__nand4_1
Xn_1917 n_0343 n_0349 n_0350 VDD VDD VSS VSS gf180mcu_fd_sc_mcu7t5v0__nor2_1
Xn_1918 n_0330 n_0350 n_0351 VDD VDD VSS VSS gf180mcu_fd_sc_mcu7t5v0__nand2_1
Xn_1919 n_0485 u_cas_diff_u_diff1_in_min1_b7 n_0484 u_cas_diff_u_diff1_in_min1_b6 n_0352 VDD VDD VSS
+ VSS gf180mcu_fd_sc_mcu7t5v0__aoi211_1
Xn_1920 n_0347 out_cas_int_b6 n_0571 n_0353 VDD VDD VSS VSS gf180mcu_fd_sc_mcu7t5v0__nand3_1
Xn_1921 n_0341 n_0348 out_cas_int_b7 n_0572 n_0352 n_0354 VDD VDD VSS VSS
+ gf180mcu_fd_sc_mcu7t5v0__aoi221_1
Xn_1922 n_0342 n_0349 n_0485 u_cas_diff_u_diff1_in_min1_b7 n_0353 n_0355 VDD VDD VSS VSS
+ gf180mcu_fd_sc_mcu7t5v0__oai221_1
Xn_1923 n_0330 n_0350 n_0355 n_0356 VDD VDD VSS VSS gf180mcu_fd_sc_mcu7t5v0__aoi21_1
Xn_1924 n_0351 n_0354 n_0357 VDD VDD VSS VSS gf180mcu_fd_sc_mcu7t5v0__nand2_1
Xn_1925 n_0486 u_cas_diff_u_diff1_in_min1_b8 n_0358 VDD VDD VSS VSS gf180mcu_fd_sc_mcu7t5v0__nor2_1
Xn_1926 n_0486 u_cas_diff_u_diff1_in_min1_b8 n_0359 VDD VDD VSS VSS gf180mcu_fd_sc_mcu7t5v0__nand2_1
Xn_1927 out_cas_int_b8 u_cas_diff_u_diff1_in_min1_b8 n_0360 VDD VDD VSS VSS
+ gf180mcu_fd_sc_mcu7t5v0__xor2_1
Xn_1928 n_0356 n_0360 n_0023 VDD VDD VSS VSS gf180mcu_fd_sc_mcu7t5v0__xor2_1
Xn_1929 n_0487 u_cas_diff_u_diff1_in_min1_b9 n_0361 VDD VDD VSS VSS gf180mcu_fd_sc_mcu7t5v0__nand2_1
Xn_1930 out_cas_int_b9 u_cas_diff_u_diff1_in_min1_b9 n_0362 VDD VDD VSS VSS
+ gf180mcu_fd_sc_mcu7t5v0__xor2_1
Xn_1931 n_0357 n_0359 n_0358 n_0363 VDD VDD VSS VSS gf180mcu_fd_sc_mcu7t5v0__aoi21_1
Xn_1932 n_0362 n_0363 n_0024 VDD VDD VSS VSS gf180mcu_fd_sc_mcu7t5v0__xor2_1
Xn_1933 n_0360 n_0362 n_0364 VDD VDD VSS VSS gf180mcu_fd_sc_mcu7t5v0__nor2_1
Xn_1934 n_0360 n_0362 n_0365 VDD VDD VSS VSS gf180mcu_fd_sc_mcu7t5v0__or2_1
Xn_1935 n_0351 n_0354 n_0365 n_0366 VDD VDD VSS VSS gf180mcu_fd_sc_mcu7t5v0__aoi21_1
Xn_1936 n_0486 u_cas_diff_u_diff1_in_min1_b8 n_0487 u_cas_diff_u_diff1_in_min1_b9 n_0367 VDD VDD VSS
+ VSS gf180mcu_fd_sc_mcu7t5v0__oai22_1
Xn_1937 n_0361 n_0367 n_0368 VDD VDD VSS VSS gf180mcu_fd_sc_mcu7t5v0__and2_1
Xn_1938 n_0361 n_0367 n_0369 VDD VDD VSS VSS gf180mcu_fd_sc_mcu7t5v0__nand2_1
Xn_1939 n_0357 n_0364 n_0367 n_0361 n_0370 VDD VDD VSS VSS gf180mcu_fd_sc_mcu7t5v0__aoi22_1
Xn_1940 n_0356 n_0365 n_0369 n_0371 VDD VDD VSS VSS gf180mcu_fd_sc_mcu7t5v0__oai21_1
Xn_1941 n_0573 out_cas_int_b10 n_0372 VDD VDD VSS VSS gf180mcu_fd_sc_mcu7t5v0__nand2_1
Xn_1942 n_0488 u_cas_diff_u_diff1_in_min1_b10 n_0373 VDD VDD VSS VSS
+ gf180mcu_fd_sc_mcu7t5v0__nand2_1
Xn_1943 n_0372 n_0373 n_0374 VDD VDD VSS VSS gf180mcu_fd_sc_mcu7t5v0__nand2_1
Xn_1944 n_0370 n_0374 n_0001 VDD VDD VSS VSS gf180mcu_fd_sc_mcu7t5v0__xor2_1
Xn_1945 n_0489 u_cas_diff_u_diff1_in_min1_b11 n_0375 VDD VDD VSS VSS
+ gf180mcu_fd_sc_mcu7t5v0__nand2_1
Xn_1946 n_0574 out_cas_int_b11 n_0376 VDD VDD VSS VSS gf180mcu_fd_sc_mcu7t5v0__nand2_1
Xn_1947 n_0370 n_0374 n_0372 n_0377 VDD VDD VSS VSS gf180mcu_fd_sc_mcu7t5v0__oai21_1
Xn_1948 out_cas_int_b11 n_0574 n_0377 n_0002 VDD VDD VSS VSS gf180mcu_fd_sc_mcu7t5v0__xor3_1
Xn_1949 n_0488 u_cas_diff_u_diff1_in_min1_b10 n_0489 u_cas_diff_u_diff1_in_min1_b11 n_0378 VDD VDD
+ VSS VSS gf180mcu_fd_sc_mcu7t5v0__oai22_1
Xn_1950 n_0375 n_0378 n_0379 VDD VDD VSS VSS gf180mcu_fd_sc_mcu7t5v0__nand2_1
Xn_1951 n_0375 n_0378 n_0380 VDD VDD VSS VSS gf180mcu_fd_sc_mcu7t5v0__and2_1
Xn_1952 n_0372 n_0373 n_0375 n_0376 n_0381 VDD VDD VSS VSS gf180mcu_fd_sc_mcu7t5v0__and4_1
Xn_1953 n_0372 n_0373 n_0375 n_0376 n_0382 VDD VDD VSS VSS gf180mcu_fd_sc_mcu7t5v0__nand4_1
Xn_1954 n_0366 n_0368 n_0381 n_0383 VDD VDD VSS VSS gf180mcu_fd_sc_mcu7t5v0__oai21_1
Xn_1955 n_0371 n_0381 n_0380 n_0384 VDD VDD VSS VSS gf180mcu_fd_sc_mcu7t5v0__aoi21_1
Xn_1956 n_0575 out_cas_int_b12 n_0385 VDD VDD VSS VSS gf180mcu_fd_sc_mcu7t5v0__nand2_1
Xn_1957 n_0490 u_cas_diff_u_diff1_in_min1_b12 n_0386 VDD VDD VSS VSS
+ gf180mcu_fd_sc_mcu7t5v0__nand2_1
Xn_1958 out_cas_int_b12 u_cas_diff_u_diff1_in_min1_b12 n_0384 n_0003 VDD VDD VSS VSS
+ gf180mcu_fd_sc_mcu7t5v0__xor3_1
Xn_1959 n_0576 out_cas_int_b13 n_0387 VDD VDD VSS VSS gf180mcu_fd_sc_mcu7t5v0__nand2_1
Xn_1960 n_0491 u_cas_diff_u_diff1_in_min1_b13 n_0388 VDD VDD VSS VSS
+ gf180mcu_fd_sc_mcu7t5v0__nand2_1
Xn_1961 n_0383 n_0385 n_0379 n_0389 VDD VDD VSS VSS gf180mcu_fd_sc_mcu7t5v0__nand3_1
Xn_1962 n_0386 n_0389 n_0390 VDD VDD VSS VSS gf180mcu_fd_sc_mcu7t5v0__nand2_1
Xn_1963 n_0491 n_0576 n_0390 n_0004 VDD VDD VSS VSS gf180mcu_fd_sc_mcu7t5v0__xor3_1
Xn_1964 n_0385 n_0386 n_0387 n_0388 n_0391 VDD VDD VSS VSS gf180mcu_fd_sc_mcu7t5v0__and4_1
Xn_1965 n_0385 n_0386 n_0387 n_0388 n_0392 VDD VDD VSS VSS gf180mcu_fd_sc_mcu7t5v0__nand4_1
Xn_1966 n_0383 n_0379 n_0392 n_0393 VDD VDD VSS VSS gf180mcu_fd_sc_mcu7t5v0__aoi21_1
Xn_1967 n_0490 u_cas_diff_u_diff1_in_min1_b12 n_0491 u_cas_diff_u_diff1_in_min1_b13 n_0394 VDD VDD
+ VSS VSS gf180mcu_fd_sc_mcu7t5v0__oai22_1
Xn_1968 n_0388 n_0394 n_0395 VDD VDD VSS VSS gf180mcu_fd_sc_mcu7t5v0__and2_1
Xn_1969 n_0388 n_0394 n_0396 VDD VDD VSS VSS gf180mcu_fd_sc_mcu7t5v0__nand2_1
Xn_1970 n_0384 n_0392 n_0396 n_0397 VDD VDD VSS VSS gf180mcu_fd_sc_mcu7t5v0__oai21_1
Xn_1971 n_0577 out_cas_int_b14 n_0398 VDD VDD VSS VSS gf180mcu_fd_sc_mcu7t5v0__nand2_1
Xn_1972 n_0398 n_0399 VDD VDD VSS VSS gf180mcu_fd_sc_mcu7t5v0__clkinv_1
Xn_1973 n_0492 u_cas_diff_u_diff1_in_min1_b14 n_0400 VDD VDD VSS VSS
+ gf180mcu_fd_sc_mcu7t5v0__nand2_1
Xn_1974 n_0398 n_0400 n_0401 VDD VDD VSS VSS gf180mcu_fd_sc_mcu7t5v0__and2_1
Xn_1975 n_0393 n_0395 n_0401 n_0402 VDD VDD VSS VSS gf180mcu_fd_sc_mcu7t5v0__oai21_1
Xn_1976 n_0397 n_0401 n_0005 VDD VDD VSS VSS gf180mcu_fd_sc_mcu7t5v0__xor2_1
Xn_1977 n_0493 u_cas_diff_u_diff1_in_min1_b15 n_0403 VDD VDD VSS VSS
+ gf180mcu_fd_sc_mcu7t5v0__nand2_1
Xn_1978 n_0578 out_cas_int_b15 n_0404 VDD VDD VSS VSS gf180mcu_fd_sc_mcu7t5v0__nand2_1
Xn_1979 n_0403 n_0404 n_0405 VDD VDD VSS VSS gf180mcu_fd_sc_mcu7t5v0__and2_1
Xn_1980 n_0403 n_0404 n_0406 VDD VDD VSS VSS gf180mcu_fd_sc_mcu7t5v0__nand2_1
Xn_1981 n_0397 n_0401 n_0403 n_0404 n_0399 n_0407 VDD VDD VSS VSS gf180mcu_fd_sc_mcu7t5v0__aoi221_1
Xn_1982 n_0398 n_0402 n_0406 n_0408 VDD VDD VSS VSS gf180mcu_fd_sc_mcu7t5v0__aoi21_1
Xn_1983 n_0407 n_0408 n_0006 VDD VDD VSS VSS gf180mcu_fd_sc_mcu7t5v0__nor2_1
Xn_1984 n_0494 u_cas_diff_u_diff1_in_min1_b16 n_0409 VDD VDD VSS VSS gf180mcu_fd_sc_mcu7t5v0__xor2_1
Xn_1985 n_0398 n_0400 n_0403 n_0404 n_0410 VDD VDD VSS VSS gf180mcu_fd_sc_mcu7t5v0__and4_1
Xn_1986 n_0398 n_0400 n_0403 n_0404 n_0411 VDD VDD VSS VSS gf180mcu_fd_sc_mcu7t5v0__nand4_1
Xn_1987 n_0392 n_0411 n_0412 VDD VDD VSS VSS gf180mcu_fd_sc_mcu7t5v0__nor2_1
Xn_1988 n_0391 n_0401 n_0403 n_0404 n_0413 VDD VDD VSS VSS gf180mcu_fd_sc_mcu7t5v0__nand4_1
Xn_1989 n_0364 n_0381 n_0391 n_0410 n_0414 VDD VDD VSS VSS gf180mcu_fd_sc_mcu7t5v0__nand4_1
Xn_1990 n_0351 n_0354 n_0414 n_0415 VDD VDD VSS VSS gf180mcu_fd_sc_mcu7t5v0__aoi21_1
Xn_1991 n_0398 n_0404 n_0416 VDD VDD VSS VSS gf180mcu_fd_sc_mcu7t5v0__nand2_1
Xn_1992 n_0403 n_0416 n_0417 VDD VDD VSS VSS gf180mcu_fd_sc_mcu7t5v0__and2_1
Xn_1993 n_0403 n_0416 n_0418 VDD VDD VSS VSS gf180mcu_fd_sc_mcu7t5v0__nand2_1
Xn_1994 n_0368 n_0381 n_0378 n_0375 n_0419 VDD VDD VSS VSS gf180mcu_fd_sc_mcu7t5v0__aoi22_1
Xn_1995 n_0369 n_0382 n_0379 n_0420 VDD VDD VSS VSS gf180mcu_fd_sc_mcu7t5v0__oai21_1
Xn_1996 n_0396 n_0411 n_0421 VDD VDD VSS VSS gf180mcu_fd_sc_mcu7t5v0__nor2_1
Xn_1997 n_0401 n_0405 n_0388 n_0394 n_0422 VDD VDD VSS VSS gf180mcu_fd_sc_mcu7t5v0__nand4_1
Xn_1998 n_0412 n_0420 n_0421 n_0417 n_0423 VDD VDD VSS VSS gf180mcu_fd_sc_mcu7t5v0__aoi211_1
Xn_1999 n_0419 n_0413 n_0418 n_0422 n_0424 VDD VDD VSS VSS gf180mcu_fd_sc_mcu7t5v0__oai211_1
Xn_2000 n_0356 n_0414 n_0423 n_0425 VDD VDD VSS VSS gf180mcu_fd_sc_mcu7t5v0__oai21_1
Xn_2001 n_0425 n_0409 n_0426 VDD VDD VSS VSS gf180mcu_fd_sc_mcu7t5v0__nand2_1
Xn_2002 n_0409 n_0425 n_0007 VDD VDD VSS VSS gf180mcu_fd_sc_mcu7t5v0__xor2_1
Xn_2003 n_0579 out_cas_int_b17 n_0427 VDD VDD VSS VSS gf180mcu_fd_sc_mcu7t5v0__nand2_1
Xn_2004 n_0579 out_cas_int_b17 n_0428 VDD VDD VSS VSS gf180mcu_fd_sc_mcu7t5v0__nor2_1
Xn_2005 out_cas_int_b17 n_0579 n_0429 VDD VDD VSS VSS gf180mcu_fd_sc_mcu7t5v0__xor2_1
Xn_2006 n_0494 u_cas_diff_u_diff1_in_min1_b16 n_0426 n_0430 VDD VDD VSS VSS
+ gf180mcu_fd_sc_mcu7t5v0__oai21_1
Xn_2007 n_0429 n_0430 n_0008 VDD VDD VSS VSS gf180mcu_fd_sc_mcu7t5v0__xor2_1
Xn_2008 n_0409 n_0429 n_0431 VDD VDD VSS VSS gf180mcu_fd_sc_mcu7t5v0__and2_1
Xn_2009 n_0428 n_0494 u_cas_diff_u_diff1_in_min1_b16 n_0427 n_0432 VDD VDD VSS VSS
+ gf180mcu_fd_sc_mcu7t5v0__oai31_1
Xn_2010 n_0425 n_0431 n_0432 n_0433 VDD VDD VSS VSS gf180mcu_fd_sc_mcu7t5v0__aoi21_1
Xn_2011 n_0580 out_cas_int_b18 n_0434 VDD VDD VSS VSS gf180mcu_fd_sc_mcu7t5v0__nand2_1
Xn_2012 out_cas_int_b18 u_cas_diff_u_diff1_in_min1_b18 n_0435 VDD VDD VSS VSS
+ gf180mcu_fd_sc_mcu7t5v0__xor2_1
Xn_2013 n_0433 n_0435 n_0009 VDD VDD VSS VSS gf180mcu_fd_sc_mcu7t5v0__xor2_1
Xn_2014 n_0433 n_0435 n_0434 n_0436 VDD VDD VSS VSS gf180mcu_fd_sc_mcu7t5v0__oai21_1
Xn_2015 out_cas_int_b19 u_cas_diff_u_diff1_in_min1_b19 n_0437 VDD VDD VSS VSS
+ gf180mcu_fd_sc_mcu7t5v0__xor2_1
Xn_2016 n_0436 n_0437 n_0010 VDD VDD VSS VSS gf180mcu_fd_sc_mcu7t5v0__xnor2_1
Xn_2017 n_0582 out_cas_int_b20 n_0438 VDD VDD VSS VSS gf180mcu_fd_sc_mcu7t5v0__nand2_1
Xn_2018 n_0582 out_cas_int_b20 n_0439 VDD VDD VSS VSS gf180mcu_fd_sc_mcu7t5v0__or2_1
Xn_2019 n_0438 n_0439 n_0440 VDD VDD VSS VSS gf180mcu_fd_sc_mcu7t5v0__nand2_1
Xn_2020 n_0581 out_cas_int_b19 out_cas_int_b18 n_0441 VDD VDD VSS VSS
+ gf180mcu_fd_sc_mcu7t5v0__oai21_1
Xn_2021 n_0441 u_cas_diff_u_diff1_in_min1_b18 n_0442 VDD VDD VSS VSS gf180mcu_fd_sc_mcu7t5v0__nor2_1
Xn_2022 n_0435 n_0437 n_0443 VDD VDD VSS VSS gf180mcu_fd_sc_mcu7t5v0__nor2_1
Xn_2023 n_0432 n_0443 out_cas_int_b19 n_0581 n_0444 VDD VDD VSS VSS gf180mcu_fd_sc_mcu7t5v0__aoi22_1
Xn_2024 n_0432 n_0443 out_cas_int_b19 n_0581 n_0442 n_0445 VDD VDD VSS VSS
+ gf180mcu_fd_sc_mcu7t5v0__aoi221_1
Xn_2025 u_cas_diff_u_diff1_in_min1_b18 n_0441 n_0444 n_0446 VDD VDD VSS VSS
+ gf180mcu_fd_sc_mcu7t5v0__oai21_1
Xn_2026 n_0409 n_0429 n_0443 n_0447 VDD VDD VSS VSS gf180mcu_fd_sc_mcu7t5v0__and3_1
Xn_2027 n_0415 n_0424 n_0447 n_0448 VDD VDD VSS VSS gf180mcu_fd_sc_mcu7t5v0__oai21_1
Xn_2028 n_0425 n_0447 n_0446 n_0449 VDD VDD VSS VSS gf180mcu_fd_sc_mcu7t5v0__aoi21_1
Xn_2029 n_0440 n_0449 n_0012 VDD VDD VSS VSS gf180mcu_fd_sc_mcu7t5v0__xor2_1
Xn_2030 n_0440 n_0449 n_0438 n_0450 VDD VDD VSS VSS gf180mcu_fd_sc_mcu7t5v0__oai21_1
Xn_2031 n_0583 out_cas_int_b21 n_0451 VDD VDD VSS VSS gf180mcu_fd_sc_mcu7t5v0__nand2_1
Xn_2032 n_0583 out_cas_int_b21 n_0452 VDD VDD VSS VSS gf180mcu_fd_sc_mcu7t5v0__or2_1
Xn_2033 out_cas_int_b21 n_0583 n_0450 n_0013 VDD VDD VSS VSS gf180mcu_fd_sc_mcu7t5v0__xor3_1
Xn_2034 n_0495 u_cas_diff_u_diff1_in_min1_b22 n_0453 VDD VDD VSS VSS gf180mcu_fd_sc_mcu7t5v0__nor2_1
Xn_2035 n_0584 out_cas_int_b22 n_0454 VDD VDD VSS VSS gf180mcu_fd_sc_mcu7t5v0__nand2_1
Xn_2036 n_0584 out_cas_int_b22 n_0455 VDD VDD VSS VSS gf180mcu_fd_sc_mcu7t5v0__nor2_1
Xn_2037 n_0453 n_0455 n_0456 VDD VDD VSS VSS gf180mcu_fd_sc_mcu7t5v0__nor2_1
Xn_2038 n_0438 n_0439 n_0451 n_0452 n_0457 VDD VDD VSS VSS gf180mcu_fd_sc_mcu7t5v0__nand4_1
Xn_2039 n_0448 n_0445 n_0457 n_0458 VDD VDD VSS VSS gf180mcu_fd_sc_mcu7t5v0__aoi21_1
Xn_2040 n_0452 out_cas_int_b20 n_0582 n_0459 VDD VDD VSS VSS gf180mcu_fd_sc_mcu7t5v0__nand3_1
Xn_2041 n_0451 n_0459 n_0460 VDD VDD VSS VSS gf180mcu_fd_sc_mcu7t5v0__nand2_1
Xn_2042 n_0460 n_0461 VDD VDD VSS VSS gf180mcu_fd_sc_mcu7t5v0__clkinv_1
Xn_2043 n_0449 n_0457 n_0461 n_0462 VDD VDD VSS VSS gf180mcu_fd_sc_mcu7t5v0__oai21_1
Xn_2044 n_0458 n_0460 n_0456 n_0463 VDD VDD VSS VSS gf180mcu_fd_sc_mcu7t5v0__oai21_1
Xn_2045 n_0456 n_0462 n_0014 VDD VDD VSS VSS gf180mcu_fd_sc_mcu7t5v0__xor2_1
Xn_2046 out_cas_int_b23 n_0585 n_0464 VDD VDD VSS VSS gf180mcu_fd_sc_mcu7t5v0__xor2_1
Xn_2047 out_cas_int_b23 u_cas_diff_u_diff1_in_min1_b23 n_0465 VDD VDD VSS VSS
+ gf180mcu_fd_sc_mcu7t5v0__xor2_1
Xn_2048 n_0462 n_0456 n_0453 n_0464 n_0466 VDD VDD VSS VSS gf180mcu_fd_sc_mcu7t5v0__aoi211_1
Xn_2049 n_0454 n_0463 n_0465 n_0467 VDD VDD VSS VSS gf180mcu_fd_sc_mcu7t5v0__aoi21_1
Xn_2050 n_0466 n_0467 n_0015 VDD VDD VSS VSS gf180mcu_fd_sc_mcu7t5v0__nor2_1
Xn_2051 n_0465 n_0455 n_0453 n_0468 VDD VDD VSS VSS gf180mcu_fd_sc_mcu7t5v0__nor3_1
Xn_2052 n_0458 n_0460 n_0468 n_0469 VDD VDD VSS VSS gf180mcu_fd_sc_mcu7t5v0__oai21_1
Xn_2053 n_0496 u_cas_diff_u_diff1_in_min1_b23 n_0495 u_cas_diff_u_diff1_in_min1_b22 n_0470 VDD VDD
+ VSS VSS gf180mcu_fd_sc_mcu7t5v0__aoi211_1
Xn_2054 n_0585 out_cas_int_b23 n_0584 out_cas_int_b22 n_0471 VDD VDD VSS VSS
+ gf180mcu_fd_sc_mcu7t5v0__oai211_1
Xn_2055 out_cas_int_b23 n_0585 n_0470 n_0472 VDD VDD VSS VSS gf180mcu_fd_sc_mcu7t5v0__aoi21_1
Xn_2056 n_0496 u_cas_diff_u_diff1_in_min1_b23 n_0471 n_0473 VDD VDD VSS VSS
+ gf180mcu_fd_sc_mcu7t5v0__oai21_1
Xn_2057 out_cas_int_b24 u_cas_diff_u_diff1_in_min1_b24 n_0474 VDD VDD VSS VSS
+ gf180mcu_fd_sc_mcu7t5v0__xor2_1
Xn_2058 out_cas_int_b24 u_cas_diff_u_diff1_in_min1_b24 n_0475 VDD VDD VSS VSS
+ gf180mcu_fd_sc_mcu7t5v0__xnor2_1
Xn_2059 n_0469 n_0472 n_0474 n_0476 VDD VDD VSS VSS gf180mcu_fd_sc_mcu7t5v0__aoi21_1
Xn_2060 n_0462 n_0468 n_0473 n_0475 n_0477 VDD VDD VSS VSS gf180mcu_fd_sc_mcu7t5v0__aoi211_1
Xn_2061 n_0476 n_0477 n_0016 VDD VDD VSS VSS gf180mcu_fd_sc_mcu7t5v0__nor2_1
Xn_2062 u_clock_div_counter_b3 n_0587 n_0140 VDD VDD VSS VSS gf180mcu_fd_sc_mcu7t5v0__xnor2_1
Xn_2063 u_cas_int_out_int2_b0 out_cas_int_b0 n_0112 VDD VDD VSS VSS gf180mcu_fd_sc_mcu7t5v0__xor2_1
Xn_2064 u_clock_div_counter_b2 n_0586 n_0139 VDD VDD VSS VSS gf180mcu_fd_sc_mcu7t5v0__xnor2_1
Xn_2065 out_cas_int_b0 u_cas_diff_u_diff1_in_min1_b0 n_0000 VDD VDD VSS VSS
+ gf180mcu_fd_sc_mcu7t5v0__xor2_1
Xn_2066 u_clock_div_counter_b0 u_clock_div_counter_b1 n_0138 VDD VDD VSS VSS
+ gf180mcu_fd_sc_mcu7t5v0__xor2_1
Xn_2067 u_cas_int_out_int1_b0 net1 n_0062 VDD VDD VSS VSS gf180mcu_fd_sc_mcu7t5v0__xor2_1
Xn_2068 u_cas_int_out_int2_b0 u_cas_int_out_int1_b0 n_0087 VDD VDD VSS VSS
+ gf180mcu_fd_sc_mcu7t5v0__xor2_1
Xn_2069 u_cas_diff_u_diff2_in_min1_b0 u_cas_diff_out_diff1_b0 n_0025 VDD VDD VSS VSS
+ gf180mcu_fd_sc_mcu7t5v0__xor2_1
Xn_2070 n_0112 net21 clknet_3_2__leaf_clk out_cas_int_b0 VDD VDD VSS VSS
+ gf180mcu_fd_sc_mcu7t5v0__dffrnq_1
Xn_2071 n_0123 net21 clknet_3_2__leaf_clk out_cas_int_b1 VDD VDD VSS VSS
+ gf180mcu_fd_sc_mcu7t5v0__dffrnq_1
Xn_2072 n_0129 net18 clknet_3_2__leaf_clk out_cas_int_b2 VDD VDD VSS VSS
+ gf180mcu_fd_sc_mcu7t5v0__dffrnq_1
Xn_2073 n_0130 net18 clknet_3_2__leaf_clk out_cas_int_b3 VDD VDD VSS VSS
+ gf180mcu_fd_sc_mcu7t5v0__dffrnq_1
Xn_2074 n_0131 net18 clknet_3_2__leaf_clk out_cas_int_b4 VDD VDD VSS VSS
+ gf180mcu_fd_sc_mcu7t5v0__dffrnq_1
Xn_2075 n_0132 net18 clknet_3_2__leaf_clk out_cas_int_b5 VDD VDD VSS VSS
+ gf180mcu_fd_sc_mcu7t5v0__dffrnq_1
Xn_2076 n_0133 net18 clknet_3_3__leaf_clk out_cas_int_b6 VDD VDD VSS VSS
+ gf180mcu_fd_sc_mcu7t5v0__dffrnq_1
Xn_2077 n_0134 net18 clknet_3_3__leaf_clk out_cas_int_b7 VDD VDD VSS VSS
+ gf180mcu_fd_sc_mcu7t5v0__dffrnq_1
Xn_2078 n_0135 net18 clknet_3_3__leaf_clk out_cas_int_b8 VDD VDD VSS VSS
+ gf180mcu_fd_sc_mcu7t5v0__dffrnq_1
Xn_2079 n_0136 net18 clknet_3_3__leaf_clk out_cas_int_b9 VDD VDD VSS VSS
+ gf180mcu_fd_sc_mcu7t5v0__dffrnq_1
Xn_2080 n_0113 net18 clknet_3_3__leaf_clk out_cas_int_b10 VDD VDD VSS VSS
+ gf180mcu_fd_sc_mcu7t5v0__dffrnq_1
Xn_2081 n_0114 net18 clknet_3_3__leaf_clk out_cas_int_b11 VDD VDD VSS VSS
+ gf180mcu_fd_sc_mcu7t5v0__dffrnq_1
Xn_2082 n_0115 net18 clknet_3_3__leaf_clk out_cas_int_b12 VDD VDD VSS VSS
+ gf180mcu_fd_sc_mcu7t5v0__dffrnq_1
Xn_2083 n_0116 net18 clknet_3_6__leaf_clk out_cas_int_b13 VDD VDD VSS VSS
+ gf180mcu_fd_sc_mcu7t5v0__dffrnq_1
Xn_2084 n_0117 net18 clknet_3_6__leaf_clk out_cas_int_b14 VDD VDD VSS VSS
+ gf180mcu_fd_sc_mcu7t5v0__dffrnq_1
Xn_2085 n_0118 net18 clknet_3_6__leaf_clk out_cas_int_b15 VDD VDD VSS VSS
+ gf180mcu_fd_sc_mcu7t5v0__dffrnq_1
Xn_2086 n_0119 net18 clknet_3_6__leaf_clk out_cas_int_b16 VDD VDD VSS VSS
+ gf180mcu_fd_sc_mcu7t5v0__dffrnq_1
Xn_2087 n_0120 net18 clknet_3_7__leaf_clk out_cas_int_b17 VDD VDD VSS VSS
+ gf180mcu_fd_sc_mcu7t5v0__dffrnq_1
Xn_2088 n_0121 net18 clknet_3_7__leaf_clk out_cas_int_b18 VDD VDD VSS VSS
+ gf180mcu_fd_sc_mcu7t5v0__dffrnq_1
Xn_2089 n_0122 net18 clknet_3_7__leaf_clk out_cas_int_b19 VDD VDD VSS VSS
+ gf180mcu_fd_sc_mcu7t5v0__dffrnq_1
Xn_2090 n_0124 net18 clknet_3_7__leaf_clk out_cas_int_b20 VDD VDD VSS VSS
+ gf180mcu_fd_sc_mcu7t5v0__dffrnq_1
Xn_2091 n_0125 net18 clknet_3_7__leaf_clk out_cas_int_b21 VDD VDD VSS VSS
+ gf180mcu_fd_sc_mcu7t5v0__dffrnq_1
Xn_2092 n_0126 net18 clknet_3_7__leaf_clk out_cas_int_b22 VDD VDD VSS VSS
+ gf180mcu_fd_sc_mcu7t5v0__dffrnq_1
Xn_2093 n_0127 net18 clknet_3_7__leaf_clk out_cas_int_b23 VDD VDD VSS VSS
+ gf180mcu_fd_sc_mcu7t5v0__dffrnq_1
Xn_2094 n_0128 net18 clknet_3_7__leaf_clk out_cas_int_b24 VDD VDD VSS VSS
+ gf180mcu_fd_sc_mcu7t5v0__dffrnq_1
Xn_2095 n_0087 net17 clknet_3_2__leaf_clk u_cas_int_out_int2_b0 VDD VDD VSS VSS
+ gf180mcu_fd_sc_mcu7t5v0__dffrnq_1
Xn_2096 n_0098 net17 clknet_3_2__leaf_clk u_cas_int_out_int2_b1 VDD VDD VSS VSS
+ gf180mcu_fd_sc_mcu7t5v0__dffrnq_1
Xn_2097 n_0104 net21 clknet_3_2__leaf_clk u_cas_int_out_int2_b2 VDD VDD VSS VSS
+ gf180mcu_fd_sc_mcu7t5v0__dffrnq_1
Xn_2098 n_0105 net21 clknet_3_2__leaf_clk u_cas_int_out_int2_b3 VDD VDD VSS VSS
+ gf180mcu_fd_sc_mcu7t5v0__dffrnq_1
Xn_2099 n_0106 net21 clknet_3_2__leaf_clk u_cas_int_out_int2_b4 VDD VDD VSS VSS
+ gf180mcu_fd_sc_mcu7t5v0__dffrnq_1
Xn_2100 n_0107 net21 clknet_3_2__leaf_clk u_cas_int_out_int2_b5 VDD VDD VSS VSS
+ gf180mcu_fd_sc_mcu7t5v0__dffrnq_1
Xn_2101 n_0108 net21 clknet_3_3__leaf_clk u_cas_int_out_int2_b6 VDD VDD VSS VSS
+ gf180mcu_fd_sc_mcu7t5v0__dffrnq_1
Xn_2102 n_0109 net21 clknet_3_3__leaf_clk u_cas_int_out_int2_b7 VDD VDD VSS VSS
+ gf180mcu_fd_sc_mcu7t5v0__dffrnq_1
Xn_2103 n_0110 net21 clknet_3_1__leaf_clk u_cas_int_out_int2_b8 VDD VDD VSS VSS
+ gf180mcu_fd_sc_mcu7t5v0__dffrnq_1
Xn_2104 n_0111 net21 clknet_3_1__leaf_clk u_cas_int_out_int2_b9 VDD VDD VSS VSS
+ gf180mcu_fd_sc_mcu7t5v0__dffrnq_1
Xn_2105 n_0088 net21 clknet_3_1__leaf_clk u_cas_int_out_int2_b10 VDD VDD VSS VSS
+ gf180mcu_fd_sc_mcu7t5v0__dffrnq_1
Xn_2106 n_0089 net21 clknet_3_1__leaf_clk u_cas_int_out_int2_b11 VDD VDD VSS VSS
+ gf180mcu_fd_sc_mcu7t5v0__dffrnq_1
Xn_2107 n_0090 net21 clknet_3_1__leaf_clk u_cas_int_out_int2_b12 VDD VDD VSS VSS
+ gf180mcu_fd_sc_mcu7t5v0__dffrnq_1
Xn_2108 n_0091 net21 clknet_3_6__leaf_clk u_cas_int_out_int2_b13 VDD VDD VSS VSS
+ gf180mcu_fd_sc_mcu7t5v0__dffrnq_1
Xn_2109 n_0092 net21 clknet_3_4__leaf_clk u_cas_int_out_int2_b14 VDD VDD VSS VSS
+ gf180mcu_fd_sc_mcu7t5v0__dffrnq_1
Xn_2110 n_0093 net21 clknet_3_4__leaf_clk u_cas_int_out_int2_b15 VDD VDD VSS VSS
+ gf180mcu_fd_sc_mcu7t5v0__dffrnq_1
Xn_2111 n_0094 net21 clknet_3_6__leaf_clk u_cas_int_out_int2_b16 VDD VDD VSS VSS
+ gf180mcu_fd_sc_mcu7t5v0__dffrnq_1
Xn_2112 n_0095 net21 clknet_3_4__leaf_clk u_cas_int_out_int2_b17 VDD VDD VSS VSS
+ gf180mcu_fd_sc_mcu7t5v0__dffrnq_1
Xn_2113 n_0096 net21 clknet_3_6__leaf_clk u_cas_int_out_int2_b18 VDD VDD VSS VSS
+ gf180mcu_fd_sc_mcu7t5v0__dffrnq_1
Xn_2114 n_0097 net21 clknet_3_5__leaf_clk u_cas_int_out_int2_b19 VDD VDD VSS VSS
+ gf180mcu_fd_sc_mcu7t5v0__dffrnq_1
Xn_2115 n_0099 net21 clknet_3_5__leaf_clk u_cas_int_out_int2_b20 VDD VDD VSS VSS
+ gf180mcu_fd_sc_mcu7t5v0__dffrnq_1
Xn_2116 n_0100 net21 clknet_3_5__leaf_clk u_cas_int_out_int2_b21 VDD VDD VSS VSS
+ gf180mcu_fd_sc_mcu7t5v0__dffrnq_1
Xn_2117 n_0101 net21 clknet_3_5__leaf_clk u_cas_int_out_int2_b22 VDD VDD VSS VSS
+ gf180mcu_fd_sc_mcu7t5v0__dffrnq_1
Xn_2118 n_0102 net21 clknet_3_5__leaf_clk u_cas_int_out_int2_b23 VDD VDD VSS VSS
+ gf180mcu_fd_sc_mcu7t5v0__dffrnq_1
Xn_2119 n_0103 net21 clknet_3_5__leaf_clk u_cas_int_out_int2_b24 VDD VDD VSS VSS
+ gf180mcu_fd_sc_mcu7t5v0__dffrnq_1
Xn_2120 n_0062 net17 clknet_3_0__leaf_clk u_cas_int_out_int1_b0 VDD VDD VSS VSS
+ gf180mcu_fd_sc_mcu7t5v0__dffrnq_1
Xn_2121 n_0073 net17 clknet_3_0__leaf_clk u_cas_int_out_int1_b1 VDD VDD VSS VSS
+ gf180mcu_fd_sc_mcu7t5v0__dffrnq_1
Xn_2122 n_0079 net17 clknet_3_0__leaf_clk u_cas_int_out_int1_b2 VDD VDD VSS VSS
+ gf180mcu_fd_sc_mcu7t5v0__dffrnq_1
Xn_2123 n_0080 net17 clknet_3_0__leaf_clk u_cas_int_out_int1_b3 VDD VDD VSS VSS
+ gf180mcu_fd_sc_mcu7t5v0__dffrnq_1
Xn_2124 n_0081 net17 clknet_3_0__leaf_clk u_cas_int_out_int1_b4 VDD VDD VSS VSS
+ gf180mcu_fd_sc_mcu7t5v0__dffrnq_1
Xn_2125 n_0082 net17 clknet_3_0__leaf_clk u_cas_int_out_int1_b5 VDD VDD VSS VSS
+ gf180mcu_fd_sc_mcu7t5v0__dffrnq_1
Xn_2126 n_0083 net17 clknet_3_0__leaf_clk u_cas_int_out_int1_b6 VDD VDD VSS VSS
+ gf180mcu_fd_sc_mcu7t5v0__dffrnq_1
Xn_2127 n_0084 net17 clknet_3_0__leaf_clk u_cas_int_out_int1_b7 VDD VDD VSS VSS
+ gf180mcu_fd_sc_mcu7t5v0__dffrnq_1
Xn_2128 n_0085 net17 clknet_3_1__leaf_clk u_cas_int_out_int1_b8 VDD VDD VSS VSS
+ gf180mcu_fd_sc_mcu7t5v0__dffrnq_1
Xn_2129 n_0086 net17 clknet_3_1__leaf_clk u_cas_int_out_int1_b9 VDD VDD VSS VSS
+ gf180mcu_fd_sc_mcu7t5v0__dffrnq_1
Xn_2130 n_0063 net17 clknet_3_1__leaf_clk u_cas_int_out_int1_b10 VDD VDD VSS VSS
+ gf180mcu_fd_sc_mcu7t5v0__dffrnq_1
Xn_2131 n_0064 net17 clknet_3_1__leaf_clk u_cas_int_out_int1_b11 VDD VDD VSS VSS
+ gf180mcu_fd_sc_mcu7t5v0__dffrnq_1
Xn_2132 n_0065 net17 clknet_3_4__leaf_clk u_cas_int_out_int1_b12 VDD VDD VSS VSS
+ gf180mcu_fd_sc_mcu7t5v0__dffrnq_1
Xn_2133 n_0066 net17 clknet_3_4__leaf_clk u_cas_int_out_int1_b13 VDD VDD VSS VSS
+ gf180mcu_fd_sc_mcu7t5v0__dffrnq_1
Xn_2134 n_0067 net17 clknet_3_4__leaf_clk u_cas_int_out_int1_b14 VDD VDD VSS VSS
+ gf180mcu_fd_sc_mcu7t5v0__dffrnq_1
Xn_2135 n_0068 net17 clknet_3_1__leaf_clk u_cas_int_out_int1_b15 VDD VDD VSS VSS
+ gf180mcu_fd_sc_mcu7t5v0__dffrnq_1
Xn_2136 n_0069 net17 clknet_3_4__leaf_clk u_cas_int_out_int1_b16 VDD VDD VSS VSS
+ gf180mcu_fd_sc_mcu7t5v0__dffrnq_1
Xn_2137 n_0070 net17 clknet_3_4__leaf_clk u_cas_int_out_int1_b17 VDD VDD VSS VSS
+ gf180mcu_fd_sc_mcu7t5v0__dffrnq_1
Xn_2138 n_0071 net17 clknet_3_4__leaf_clk u_cas_int_out_int1_b18 VDD VDD VSS VSS
+ gf180mcu_fd_sc_mcu7t5v0__dffrnq_1
Xn_2139 n_0072 net17 clknet_3_5__leaf_clk u_cas_int_out_int1_b19 VDD VDD VSS VSS
+ gf180mcu_fd_sc_mcu7t5v0__dffrnq_1
Xn_2140 n_0074 net17 clknet_3_5__leaf_clk u_cas_int_out_int1_b20 VDD VDD VSS VSS
+ gf180mcu_fd_sc_mcu7t5v0__dffrnq_1
Xn_2141 n_0075 net17 clknet_3_5__leaf_clk u_cas_int_out_int1_b21 VDD VDD VSS VSS
+ gf180mcu_fd_sc_mcu7t5v0__dffrnq_1
Xn_2142 n_0076 net17 clknet_3_5__leaf_clk u_cas_int_out_int1_b22 VDD VDD VSS VSS
+ gf180mcu_fd_sc_mcu7t5v0__dffrnq_1
Xn_2143 n_0077 net17 clknet_3_5__leaf_clk u_cas_int_out_int1_b23 VDD VDD VSS VSS
+ gf180mcu_fd_sc_mcu7t5v0__dffrnq_1
Xn_2144 n_0078 net17 clknet_3_5__leaf_clk u_cas_int_out_int1_b24 VDD VDD VSS VSS
+ gf180mcu_fd_sc_mcu7t5v0__dffrnq_1
Xn_2145 n_0137 net17 clknet_3_0__leaf_clk u_clock_div_counter_b0 VDD VDD VSS VSS
+ gf180mcu_fd_sc_mcu7t5v0__dffrnq_1
Xn_2146 n_0138 net17 clknet_3_0__leaf_clk u_clock_div_counter_b1 VDD VDD VSS VSS
+ gf180mcu_fd_sc_mcu7t5v0__dffrnq_1
Xn_2147 n_0139 net17 clknet_3_0__leaf_clk u_clock_div_counter_b2 VDD VDD VSS VSS
+ gf180mcu_fd_sc_mcu7t5v0__dffrnq_1
Xn_2148 n_0140 net17 clknet_3_0__leaf_clk u_clock_div_counter_b3 VDD VDD VSS VSS
+ gf180mcu_fd_sc_mcu7t5v0__dffrnq_1
Xn_2149 n_0141 net17 clknet_3_0__leaf_clk u_clock_div_counter_b4 VDD VDD VSS VSS
+ gf180mcu_fd_sc_mcu7t5v0__dffrnq_1
Xn_2150 n_0142 net17 clknet_3_0__leaf_clk u_clock_div_counter_b5 VDD VDD VSS VSS
+ gf180mcu_fd_sc_mcu7t5v0__dffrnq_1
Xn_2151 n_0143 net17 clknet_3_0__leaf_clk u_clock_div_counter_b6 VDD VDD VSS VSS
+ gf180mcu_fd_sc_mcu7t5v0__dffrnq_1
Xn_2152 n_0144 net21 clknet_3_2__leaf_clk u_clock_div_counter_b7 VDD VDD VSS VSS
+ gf180mcu_fd_sc_mcu7t5v0__dffrnq_2
Xn_2153 u_cas_diff_out_diff2_b0 net2 net16 u_cas_diff_u_diff3_in_min1_b0 VDD VDD VSS VSS
+ gf180mcu_fd_sc_mcu7t5v0__dffnrnq_1
Xn_2154 u_cas_diff_out_diff2_b1 net2 net16 u_cas_diff_u_diff3_in_min1_b1 VDD VDD VSS VSS
+ gf180mcu_fd_sc_mcu7t5v0__dffnrnq_1
Xn_2155 u_cas_diff_out_diff2_b2 net2 net16 u_cas_diff_u_diff3_in_min1_b2 VDD VDD VSS VSS
+ gf180mcu_fd_sc_mcu7t5v0__dffnrnq_1
Xn_2156 u_cas_diff_out_diff2_b3 net2 net16 u_cas_diff_u_diff3_in_min1_b3 VDD VDD VSS VSS
+ gf180mcu_fd_sc_mcu7t5v0__dffnrnq_1
Xn_2157 u_cas_diff_out_diff2_b4 net2 net16 u_cas_diff_u_diff3_in_min1_b4 VDD VDD VSS VSS
+ gf180mcu_fd_sc_mcu7t5v0__dffnrnq_1
Xn_2158 u_cas_diff_out_diff2_b5 net2 net16 u_cas_diff_u_diff3_in_min1_b5 VDD VDD VSS VSS
+ gf180mcu_fd_sc_mcu7t5v0__dffnrnq_1
Xn_2159 u_cas_diff_out_diff2_b6 net2 net15 u_cas_diff_u_diff3_in_min1_b6 VDD VDD VSS VSS
+ gf180mcu_fd_sc_mcu7t5v0__dffnrnq_1
Xn_2160 u_cas_diff_out_diff2_b7 net2 net15 u_cas_diff_u_diff3_in_min1_b7 VDD VDD VSS VSS
+ gf180mcu_fd_sc_mcu7t5v0__dffnrnq_1
Xn_2161 u_cas_diff_out_diff2_b8 net20 net15 u_cas_diff_u_diff3_in_min1_b8 VDD VDD VSS VSS
+ gf180mcu_fd_sc_mcu7t5v0__dffnrnq_1
Xn_2162 u_cas_diff_out_diff2_b9 net20 net15 u_cas_diff_u_diff3_in_min1_b9 VDD VDD VSS VSS
+ gf180mcu_fd_sc_mcu7t5v0__dffnrnq_1
Xn_2163 u_cas_diff_out_diff2_b10 net2 net15 u_cas_diff_u_diff3_in_min1_b10 VDD VDD VSS VSS
+ gf180mcu_fd_sc_mcu7t5v0__dffnrnq_1
Xn_2164 u_cas_diff_out_diff2_b11 net20 net15 u_cas_diff_u_diff3_in_min1_b11 VDD VDD VSS VSS
+ gf180mcu_fd_sc_mcu7t5v0__dffnrnq_1
Xn_2165 u_cas_diff_out_diff2_b12 net20 net15 u_cas_diff_u_diff3_in_min1_b12 VDD VDD VSS VSS
+ gf180mcu_fd_sc_mcu7t5v0__dffnrnq_1
Xn_2166 u_cas_diff_out_diff2_b13 net20 net15 u_cas_diff_u_diff3_in_min1_b13 VDD VDD VSS VSS
+ gf180mcu_fd_sc_mcu7t5v0__dffnrnq_1
Xn_2167 u_cas_diff_out_diff2_b14 net20 net15 u_cas_diff_u_diff3_in_min1_b14 VDD VDD VSS VSS
+ gf180mcu_fd_sc_mcu7t5v0__dffnrnq_1
Xn_2168 u_cas_diff_out_diff2_b15 net20 net15 u_cas_diff_u_diff3_in_min1_b15 VDD VDD VSS VSS
+ gf180mcu_fd_sc_mcu7t5v0__dffnrnq_1
Xn_2169 u_cas_diff_out_diff2_b16 net20 net15 u_cas_diff_u_diff3_in_min1_b16 VDD VDD VSS VSS
+ gf180mcu_fd_sc_mcu7t5v0__dffnrnq_1
Xn_2170 u_cas_diff_out_diff2_b17 net20 net15 u_cas_diff_u_diff3_in_min1_b17 VDD VDD VSS VSS
+ gf180mcu_fd_sc_mcu7t5v0__dffnrnq_1
Xn_2171 u_cas_diff_out_diff2_b18 net20 net15 u_cas_diff_u_diff3_in_min1_b18 VDD VDD VSS VSS
+ gf180mcu_fd_sc_mcu7t5v0__dffnrnq_1
Xn_2172 u_cas_diff_out_diff2_b19 net2 net15 u_cas_diff_u_diff3_in_min1_b19 VDD VDD VSS VSS
+ gf180mcu_fd_sc_mcu7t5v0__dffnrnq_1
Xn_2173 u_cas_diff_out_diff2_b20 net20 net15 u_cas_diff_u_diff3_in_min1_b20 VDD VDD VSS VSS
+ gf180mcu_fd_sc_mcu7t5v0__dffnrnq_1
Xn_2174 u_cas_diff_out_diff2_b21 net20 net15 u_cas_diff_u_diff3_in_min1_b21 VDD VDD VSS VSS
+ gf180mcu_fd_sc_mcu7t5v0__dffnrnq_1
Xn_2175 u_cas_diff_out_diff2_b22 net20 net15 u_cas_diff_u_diff3_in_min1_b22 VDD VDD VSS VSS
+ gf180mcu_fd_sc_mcu7t5v0__dffnrnq_1
Xn_2176 u_cas_diff_out_diff2_b23 net20 net15 u_cas_diff_u_diff3_in_min1_b23 VDD VDD VSS VSS
+ gf180mcu_fd_sc_mcu7t5v0__dffnrnq_1
Xn_2177 u_cas_diff_out_diff2_b24 net20 net15 u_cas_diff_u_diff3_in_min1_b24 VDD VDD VSS VSS
+ gf180mcu_fd_sc_mcu7t5v0__dffnrnq_1
Xn_2178 n_0050 net2 net15 net3 VDD VDD VSS VSS gf180mcu_fd_sc_mcu7t5v0__dffnrnq_1
Xn_2179 n_0051 net2 net15 net6 VDD VDD VSS VSS gf180mcu_fd_sc_mcu7t5v0__dffnrnq_1
Xn_2180 n_0052 net2 net15 net7 VDD VDD VSS VSS gf180mcu_fd_sc_mcu7t5v0__dffnrnq_1
Xn_2181 n_0053 net2 net15 net8 VDD VDD VSS VSS gf180mcu_fd_sc_mcu7t5v0__dffnrnq_1
Xn_2182 n_0054 net2 net15 net9 VDD VDD VSS VSS gf180mcu_fd_sc_mcu7t5v0__dffnrnq_1
Xn_2183 n_0055 net2 net15 net10 VDD VDD VSS VSS gf180mcu_fd_sc_mcu7t5v0__dffnrnq_1
Xn_2184 n_0056 net2 net15 net11 VDD VDD VSS VSS gf180mcu_fd_sc_mcu7t5v0__dffnrnq_1
Xn_2185 n_0057 net2 net15 net12 VDD VDD VSS VSS gf180mcu_fd_sc_mcu7t5v0__dffnrnq_1
Xn_2186 n_0058 net2 net15 net13 VDD VDD VSS VSS gf180mcu_fd_sc_mcu7t5v0__dffnrnq_1
Xn_2187 n_0059 net2 net15 net14 VDD VDD VSS VSS gf180mcu_fd_sc_mcu7t5v0__dffnrnq_1
Xn_2188 n_0060 net2 net15 net4 VDD VDD VSS VSS gf180mcu_fd_sc_mcu7t5v0__dffnrnq_1
Xn_2189 n_0061 net2 net15 net5 VDD VDD VSS VSS gf180mcu_fd_sc_mcu7t5v0__dffnrnq_1
Xn_2190 u_cas_diff_out_diff1_b0 net21 net16 u_cas_diff_u_diff2_in_min1_b0 VDD VDD VSS VSS
+ gf180mcu_fd_sc_mcu7t5v0__dffnrnq_1
Xn_2191 u_cas_diff_out_diff1_b1 net21 net16 u_cas_diff_u_diff2_in_min1_b1 VDD VDD VSS VSS
+ gf180mcu_fd_sc_mcu7t5v0__dffnrnq_1
Xn_2192 u_cas_diff_out_diff1_b2 net19 net16 u_cas_diff_u_diff2_in_min1_b2 VDD VDD VSS VSS
+ gf180mcu_fd_sc_mcu7t5v0__dffnrnq_1
Xn_2193 u_cas_diff_out_diff1_b3 net19 net16 u_cas_diff_u_diff2_in_min1_b3 VDD VDD VSS VSS
+ gf180mcu_fd_sc_mcu7t5v0__dffnrnq_1
Xn_2194 u_cas_diff_out_diff1_b4 net19 net16 u_cas_diff_u_diff2_in_min1_b4 VDD VDD VSS VSS
+ gf180mcu_fd_sc_mcu7t5v0__dffnrnq_1
Xn_2195 u_cas_diff_out_diff1_b5 net19 net16 u_cas_diff_u_diff2_in_min1_b5 VDD VDD VSS VSS
+ gf180mcu_fd_sc_mcu7t5v0__dffnrnq_1
Xn_2196 u_cas_diff_out_diff1_b6 net19 net16 u_cas_diff_u_diff2_in_min1_b6 VDD VDD VSS VSS
+ gf180mcu_fd_sc_mcu7t5v0__dffnrnq_1
Xn_2197 u_cas_diff_out_diff1_b7 net19 net16 u_cas_diff_u_diff2_in_min1_b7 VDD VDD VSS VSS
+ gf180mcu_fd_sc_mcu7t5v0__dffnrnq_1
Xn_2198 u_cas_diff_out_diff1_b8 net19 net16 u_cas_diff_u_diff2_in_min1_b8 VDD VDD VSS VSS
+ gf180mcu_fd_sc_mcu7t5v0__dffnrnq_1
Xn_2199 u_cas_diff_out_diff1_b9 net19 net16 u_cas_diff_u_diff2_in_min1_b9 VDD VDD VSS VSS
+ gf180mcu_fd_sc_mcu7t5v0__dffnrnq_1
Xn_2200 u_cas_diff_out_diff1_b10 net19 net16 u_cas_diff_u_diff2_in_min1_b10 VDD VDD VSS VSS
+ gf180mcu_fd_sc_mcu7t5v0__dffnrnq_1
Xn_2201 u_cas_diff_out_diff1_b11 net19 net16 u_cas_diff_u_diff2_in_min1_b11 VDD VDD VSS VSS
+ gf180mcu_fd_sc_mcu7t5v0__dffnrnq_1
Xn_2202 u_cas_diff_out_diff1_b12 net19 net16 u_cas_diff_u_diff2_in_min1_b12 VDD VDD VSS VSS
+ gf180mcu_fd_sc_mcu7t5v0__dffnrnq_1
Xn_2203 u_cas_diff_out_diff1_b13 net19 net16 u_cas_diff_u_diff2_in_min1_b13 VDD VDD VSS VSS
+ gf180mcu_fd_sc_mcu7t5v0__dffnrnq_1
Xn_2204 u_cas_diff_out_diff1_b14 net19 net16 u_cas_diff_u_diff2_in_min1_b14 VDD VDD VSS VSS
+ gf180mcu_fd_sc_mcu7t5v0__dffnrnq_1
Xn_2205 u_cas_diff_out_diff1_b15 net19 net16 u_cas_diff_u_diff2_in_min1_b15 VDD VDD VSS VSS
+ gf180mcu_fd_sc_mcu7t5v0__dffnrnq_1
Xn_2206 u_cas_diff_out_diff1_b16 net19 u_clock_div_counter_b7 u_cas_diff_u_diff2_in_min1_b16 VDD VDD
+ VSS VSS gf180mcu_fd_sc_mcu7t5v0__dffnrnq_1
Xn_2207 u_cas_diff_out_diff1_b17 net19 net16 u_cas_diff_u_diff2_in_min1_b17 VDD VDD VSS VSS
+ gf180mcu_fd_sc_mcu7t5v0__dffnrnq_1
Xn_2208 u_cas_diff_out_diff1_b18 net19 u_clock_div_counter_b7 u_cas_diff_u_diff2_in_min1_b18 VDD VDD
+ VSS VSS gf180mcu_fd_sc_mcu7t5v0__dffnrnq_1
Xn_2209 u_cas_diff_out_diff1_b19 net19 u_clock_div_counter_b7 u_cas_diff_u_diff2_in_min1_b19 VDD VDD
+ VSS VSS gf180mcu_fd_sc_mcu7t5v0__dffnrnq_1
Xn_2210 u_cas_diff_out_diff1_b20 net19 u_clock_div_counter_b7 u_cas_diff_u_diff2_in_min1_b20 VDD VDD
+ VSS VSS gf180mcu_fd_sc_mcu7t5v0__dffnrnq_1
Xn_2211 u_cas_diff_out_diff1_b21 net19 u_clock_div_counter_b7 u_cas_diff_u_diff2_in_min1_b21 VDD VDD
+ VSS VSS gf180mcu_fd_sc_mcu7t5v0__dffnrnq_1
Xn_2212 u_cas_diff_out_diff1_b22 net19 u_clock_div_counter_b7 u_cas_diff_u_diff2_in_min1_b22 VDD VDD
+ VSS VSS gf180mcu_fd_sc_mcu7t5v0__dffnrnq_1
Xn_2213 u_cas_diff_out_diff1_b23 net20 u_clock_div_counter_b7 u_cas_diff_u_diff2_in_min1_b23 VDD VDD
+ VSS VSS gf180mcu_fd_sc_mcu7t5v0__dffnrnq_1
Xn_2214 u_cas_diff_out_diff1_b24 net20 u_clock_div_counter_b7 u_cas_diff_u_diff2_in_min1_b24 VDD VDD
+ VSS VSS gf180mcu_fd_sc_mcu7t5v0__dffnrnq_1
Xn_2215 n_0025 net21 net16 u_cas_diff_out_diff2_b0 VDD VDD VSS VSS
+ gf180mcu_fd_sc_mcu7t5v0__dffnrnq_1
Xn_2216 n_0036 net21 net16 u_cas_diff_out_diff2_b1 VDD VDD VSS VSS
+ gf180mcu_fd_sc_mcu7t5v0__dffnrnq_1
Xn_2217 n_0042 net21 net16 u_cas_diff_out_diff2_b2 VDD VDD VSS VSS
+ gf180mcu_fd_sc_mcu7t5v0__dffnrnq_1
Xn_2218 n_0043 net21 net16 u_cas_diff_out_diff2_b3 VDD VDD VSS VSS
+ gf180mcu_fd_sc_mcu7t5v0__dffnrnq_1
Xn_2219 n_0044 net21 net16 u_cas_diff_out_diff2_b4 VDD VDD VSS VSS
+ gf180mcu_fd_sc_mcu7t5v0__dffnrnq_1
Xn_2220 n_0045 net2 net16 u_cas_diff_out_diff2_b5 VDD VDD VSS VSS gf180mcu_fd_sc_mcu7t5v0__dffnrnq_1
Xn_2221 n_0046 net20 net15 u_cas_diff_out_diff2_b6 VDD VDD VSS VSS
+ gf180mcu_fd_sc_mcu7t5v0__dffnrnq_1
Xn_2222 n_0047 net20 net15 u_cas_diff_out_diff2_b7 VDD VDD VSS VSS
+ gf180mcu_fd_sc_mcu7t5v0__dffnrnq_1
Xn_2223 n_0048 net20 net15 u_cas_diff_out_diff2_b8 VDD VDD VSS VSS
+ gf180mcu_fd_sc_mcu7t5v0__dffnrnq_1
Xn_2224 n_0049 net20 net15 u_cas_diff_out_diff2_b9 VDD VDD VSS VSS
+ gf180mcu_fd_sc_mcu7t5v0__dffnrnq_1
Xn_2225 n_0026 net20 net15 u_cas_diff_out_diff2_b10 VDD VDD VSS VSS
+ gf180mcu_fd_sc_mcu7t5v0__dffnrnq_1
Xn_2226 n_0027 net20 net15 u_cas_diff_out_diff2_b11 VDD VDD VSS VSS
+ gf180mcu_fd_sc_mcu7t5v0__dffnrnq_1
Xn_2227 n_0028 net20 net15 u_cas_diff_out_diff2_b12 VDD VDD VSS VSS
+ gf180mcu_fd_sc_mcu7t5v0__dffnrnq_1
Xn_2228 n_0029 net20 net15 u_cas_diff_out_diff2_b13 VDD VDD VSS VSS
+ gf180mcu_fd_sc_mcu7t5v0__dffnrnq_1
Xn_2229 n_0030 net20 net15 u_cas_diff_out_diff2_b14 VDD VDD VSS VSS
+ gf180mcu_fd_sc_mcu7t5v0__dffnrnq_1
Xn_2230 n_0031 net20 net15 u_cas_diff_out_diff2_b15 VDD VDD VSS VSS
+ gf180mcu_fd_sc_mcu7t5v0__dffnrnq_1
Xn_2231 n_0032 net20 net15 u_cas_diff_out_diff2_b16 VDD VDD VSS VSS
+ gf180mcu_fd_sc_mcu7t5v0__dffnrnq_1
Xn_2232 n_0033 net20 net15 u_cas_diff_out_diff2_b17 VDD VDD VSS VSS
+ gf180mcu_fd_sc_mcu7t5v0__dffnrnq_1
Xn_2233 n_0034 net20 net15 u_cas_diff_out_diff2_b18 VDD VDD VSS VSS
+ gf180mcu_fd_sc_mcu7t5v0__dffnrnq_1
Xn_2234 n_0035 net20 net15 u_cas_diff_out_diff2_b19 VDD VDD VSS VSS
+ gf180mcu_fd_sc_mcu7t5v0__dffnrnq_1
Xn_2235 n_0037 net20 net15 u_cas_diff_out_diff2_b20 VDD VDD VSS VSS
+ gf180mcu_fd_sc_mcu7t5v0__dffnrnq_1
Xn_2236 n_0038 net20 net15 u_cas_diff_out_diff2_b21 VDD VDD VSS VSS
+ gf180mcu_fd_sc_mcu7t5v0__dffnrnq_1
Xn_2237 n_0039 net20 net15 u_cas_diff_out_diff2_b22 VDD VDD VSS VSS
+ gf180mcu_fd_sc_mcu7t5v0__dffnrnq_1
Xn_2238 n_0040 net20 net15 u_cas_diff_out_diff2_b23 VDD VDD VSS VSS
+ gf180mcu_fd_sc_mcu7t5v0__dffnrnq_1
Xn_2239 n_0041 net20 net15 u_cas_diff_out_diff2_b24 VDD VDD VSS VSS
+ gf180mcu_fd_sc_mcu7t5v0__dffnrnq_1
Xn_2240 out_cas_int_b0 net21 net16 u_cas_diff_u_diff1_in_min1_b0 VDD VDD VSS VSS
+ gf180mcu_fd_sc_mcu7t5v0__dffnrnq_1
Xn_2241 out_cas_int_b1 net21 u_clock_div_counter_b7 u_cas_diff_u_diff1_in_min1_b1 VDD VDD VSS VSS
+ gf180mcu_fd_sc_mcu7t5v0__dffnrnq_1
Xn_2242 out_cas_int_b2 net18 u_clock_div_counter_b7 u_cas_diff_u_diff1_in_min1_b2 VDD VDD VSS VSS
+ gf180mcu_fd_sc_mcu7t5v0__dffnrnq_1
Xn_2243 out_cas_int_b3 net18 u_clock_div_counter_b7 u_cas_diff_u_diff1_in_min1_b3 VDD VDD VSS VSS
+ gf180mcu_fd_sc_mcu7t5v0__dffnrnq_1
Xn_2244 out_cas_int_b4 net18 u_clock_div_counter_b7 u_cas_diff_u_diff1_in_min1_b4 VDD VDD VSS VSS
+ gf180mcu_fd_sc_mcu7t5v0__dffnrnq_1
Xn_2245 out_cas_int_b5 net18 u_clock_div_counter_b7 u_cas_diff_u_diff1_in_min1_b5 VDD VDD VSS VSS
+ gf180mcu_fd_sc_mcu7t5v0__dffnrnq_1
Xn_2246 out_cas_int_b6 net18 u_clock_div_counter_b7 u_cas_diff_u_diff1_in_min1_b6 VDD VDD VSS VSS
+ gf180mcu_fd_sc_mcu7t5v0__dffnrnq_1
Xn_2247 out_cas_int_b7 net18 u_clock_div_counter_b7 u_cas_diff_u_diff1_in_min1_b7 VDD VDD VSS VSS
+ gf180mcu_fd_sc_mcu7t5v0__dffnrnq_1
Xn_2248 out_cas_int_b8 net18 u_clock_div_counter_b7 u_cas_diff_u_diff1_in_min1_b8 VDD VDD VSS VSS
+ gf180mcu_fd_sc_mcu7t5v0__dffnrnq_1
Xn_2249 out_cas_int_b9 net18 u_clock_div_counter_b7 u_cas_diff_u_diff1_in_min1_b9 VDD VDD VSS VSS
+ gf180mcu_fd_sc_mcu7t5v0__dffnrnq_1
Xn_2250 out_cas_int_b10 net18 u_clock_div_counter_b7 u_cas_diff_u_diff1_in_min1_b10 VDD VDD VSS VSS
+ gf180mcu_fd_sc_mcu7t5v0__dffnrnq_1
Xn_2251 out_cas_int_b11 net18 u_clock_div_counter_b7 u_cas_diff_u_diff1_in_min1_b11 VDD VDD VSS VSS
+ gf180mcu_fd_sc_mcu7t5v0__dffnrnq_1
Xn_2252 out_cas_int_b12 net18 u_clock_div_counter_b7 u_cas_diff_u_diff1_in_min1_b12 VDD VDD VSS VSS
+ gf180mcu_fd_sc_mcu7t5v0__dffnrnq_1
Xn_2253 out_cas_int_b13 net18 u_clock_div_counter_b7 u_cas_diff_u_diff1_in_min1_b13 VDD VDD VSS VSS
+ gf180mcu_fd_sc_mcu7t5v0__dffnrnq_1
Xn_2254 out_cas_int_b14 net18 u_clock_div_counter_b7 u_cas_diff_u_diff1_in_min1_b14 VDD VDD VSS VSS
+ gf180mcu_fd_sc_mcu7t5v0__dffnrnq_1
Xn_2255 out_cas_int_b15 net18 u_clock_div_counter_b7 u_cas_diff_u_diff1_in_min1_b15 VDD VDD VSS VSS
+ gf180mcu_fd_sc_mcu7t5v0__dffnrnq_1
Xn_2256 out_cas_int_b16 net18 u_clock_div_counter_b7 u_cas_diff_u_diff1_in_min1_b16 VDD VDD VSS VSS
+ gf180mcu_fd_sc_mcu7t5v0__dffnrnq_1
Xn_2257 out_cas_int_b17 net18 u_clock_div_counter_b7 u_cas_diff_u_diff1_in_min1_b17 VDD VDD VSS VSS
+ gf180mcu_fd_sc_mcu7t5v0__dffnrnq_1
Xn_2258 out_cas_int_b18 net18 u_clock_div_counter_b7 u_cas_diff_u_diff1_in_min1_b18 VDD VDD VSS VSS
+ gf180mcu_fd_sc_mcu7t5v0__dffnrnq_1
Xn_2259 out_cas_int_b19 net18 u_clock_div_counter_b7 u_cas_diff_u_diff1_in_min1_b19 VDD VDD VSS VSS
+ gf180mcu_fd_sc_mcu7t5v0__dffnrnq_1
Xn_2260 out_cas_int_b20 net18 u_clock_div_counter_b7 u_cas_diff_u_diff1_in_min1_b20 VDD VDD VSS VSS
+ gf180mcu_fd_sc_mcu7t5v0__dffnrnq_1
Xn_2261 out_cas_int_b21 net18 u_clock_div_counter_b7 u_cas_diff_u_diff1_in_min1_b21 VDD VDD VSS VSS
+ gf180mcu_fd_sc_mcu7t5v0__dffnrnq_1
Xn_2262 out_cas_int_b22 net18 u_clock_div_counter_b7 u_cas_diff_u_diff1_in_min1_b22 VDD VDD VSS VSS
+ gf180mcu_fd_sc_mcu7t5v0__dffnrnq_1
Xn_2263 out_cas_int_b23 net18 u_clock_div_counter_b7 u_cas_diff_u_diff1_in_min1_b23 VDD VDD VSS VSS
+ gf180mcu_fd_sc_mcu7t5v0__dffnrnq_1
Xn_2264 out_cas_int_b24 net20 u_clock_div_counter_b7 u_cas_diff_u_diff1_in_min1_b24 VDD VDD VSS VSS
+ gf180mcu_fd_sc_mcu7t5v0__dffnrnq_1
Xn_2265 n_0000 net21 net16 u_cas_diff_out_diff1_b0 VDD VDD VSS VSS
+ gf180mcu_fd_sc_mcu7t5v0__dffnrnq_1
Xn_2266 n_0011 net19 net16 u_cas_diff_out_diff1_b1 VDD VDD VSS VSS
+ gf180mcu_fd_sc_mcu7t5v0__dffnrnq_1
Xn_2267 n_0017 net19 net16 u_cas_diff_out_diff1_b2 VDD VDD VSS VSS
+ gf180mcu_fd_sc_mcu7t5v0__dffnrnq_1
Xn_2268 n_0018 net19 net16 u_cas_diff_out_diff1_b3 VDD VDD VSS VSS
+ gf180mcu_fd_sc_mcu7t5v0__dffnrnq_1
Xn_2269 n_0019 net19 net16 u_cas_diff_out_diff1_b4 VDD VDD VSS VSS
+ gf180mcu_fd_sc_mcu7t5v0__dffnrnq_1
Xn_2270 n_0020 net19 net16 u_cas_diff_out_diff1_b5 VDD VDD VSS VSS
+ gf180mcu_fd_sc_mcu7t5v0__dffnrnq_1
Xn_2271 n_0021 net19 net16 u_cas_diff_out_diff1_b6 VDD VDD VSS VSS
+ gf180mcu_fd_sc_mcu7t5v0__dffnrnq_1
Xn_2272 n_0022 net19 net16 u_cas_diff_out_diff1_b7 VDD VDD VSS VSS
+ gf180mcu_fd_sc_mcu7t5v0__dffnrnq_1
Xn_2273 n_0023 net19 net16 u_cas_diff_out_diff1_b8 VDD VDD VSS VSS
+ gf180mcu_fd_sc_mcu7t5v0__dffnrnq_1
Xn_2274 n_0024 net19 net16 u_cas_diff_out_diff1_b9 VDD VDD VSS VSS
+ gf180mcu_fd_sc_mcu7t5v0__dffnrnq_1
Xn_2275 n_0001 net19 net16 u_cas_diff_out_diff1_b10 VDD VDD VSS VSS
+ gf180mcu_fd_sc_mcu7t5v0__dffnrnq_1
Xn_2276 n_0002 net19 net16 u_cas_diff_out_diff1_b11 VDD VDD VSS VSS
+ gf180mcu_fd_sc_mcu7t5v0__dffnrnq_1
Xn_2277 n_0003 net19 net16 u_cas_diff_out_diff1_b12 VDD VDD VSS VSS
+ gf180mcu_fd_sc_mcu7t5v0__dffnrnq_1
Xn_2278 n_0004 net19 net16 u_cas_diff_out_diff1_b13 VDD VDD VSS VSS
+ gf180mcu_fd_sc_mcu7t5v0__dffnrnq_1
Xn_2279 n_0005 net19 net16 u_cas_diff_out_diff1_b14 VDD VDD VSS VSS
+ gf180mcu_fd_sc_mcu7t5v0__dffnrnq_1
Xn_2280 n_0006 net19 net16 u_cas_diff_out_diff1_b15 VDD VDD VSS VSS
+ gf180mcu_fd_sc_mcu7t5v0__dffnrnq_1
Xn_2281 n_0007 net19 u_clock_div_counter_b7 u_cas_diff_out_diff1_b16 VDD VDD VSS VSS
+ gf180mcu_fd_sc_mcu7t5v0__dffnrnq_1
Xn_2282 n_0008 net19 u_clock_div_counter_b7 u_cas_diff_out_diff1_b17 VDD VDD VSS VSS
+ gf180mcu_fd_sc_mcu7t5v0__dffnrnq_1
Xn_2283 n_0009 net19 u_clock_div_counter_b7 u_cas_diff_out_diff1_b18 VDD VDD VSS VSS
+ gf180mcu_fd_sc_mcu7t5v0__dffnrnq_1
Xn_2284 n_0010 net19 u_clock_div_counter_b7 u_cas_diff_out_diff1_b19 VDD VDD VSS VSS
+ gf180mcu_fd_sc_mcu7t5v0__dffnrnq_1
Xn_2285 n_0012 net19 u_clock_div_counter_b7 u_cas_diff_out_diff1_b20 VDD VDD VSS VSS
+ gf180mcu_fd_sc_mcu7t5v0__dffnrnq_1
Xn_2286 n_0013 net19 u_clock_div_counter_b7 u_cas_diff_out_diff1_b21 VDD VDD VSS VSS
+ gf180mcu_fd_sc_mcu7t5v0__dffnrnq_1
Xn_2287 n_0014 net19 u_clock_div_counter_b7 u_cas_diff_out_diff1_b22 VDD VDD VSS VSS
+ gf180mcu_fd_sc_mcu7t5v0__dffnrnq_1
Xn_2288 n_0015 net20 u_clock_div_counter_b7 u_cas_diff_out_diff1_b23 VDD VDD VSS VSS
+ gf180mcu_fd_sc_mcu7t5v0__dffnrnq_1
Xn_2289 n_0016 net20 u_clock_div_counter_b7 u_cas_diff_out_diff1_b24 VDD VDD VSS VSS
+ gf180mcu_fd_sc_mcu7t5v0__dffnrnq_1
Xclkbuf_0_clk clk clknet_0_clk VDD VDD VSS VSS gf180mcu_fd_sc_mcu7t5v0__clkbuf_16
Xclkbuf_3_0__f_clk clknet_0_clk clknet_3_0__leaf_clk VDD VDD VSS VSS
+ gf180mcu_fd_sc_mcu7t5v0__clkbuf_16
Xclkbuf_3_1__f_clk clknet_0_clk clknet_3_1__leaf_clk VDD VDD VSS VSS
+ gf180mcu_fd_sc_mcu7t5v0__clkbuf_16
Xclkbuf_3_2__f_clk clknet_0_clk clknet_3_2__leaf_clk VDD VDD VSS VSS
+ gf180mcu_fd_sc_mcu7t5v0__clkbuf_16
Xclkbuf_3_3__f_clk clknet_0_clk clknet_3_3__leaf_clk VDD VDD VSS VSS
+ gf180mcu_fd_sc_mcu7t5v0__clkbuf_16
Xclkbuf_3_4__f_clk clknet_0_clk clknet_3_4__leaf_clk VDD VDD VSS VSS
+ gf180mcu_fd_sc_mcu7t5v0__clkbuf_16
Xclkbuf_3_5__f_clk clknet_0_clk clknet_3_5__leaf_clk VDD VDD VSS VSS
+ gf180mcu_fd_sc_mcu7t5v0__clkbuf_16
Xclkbuf_3_6__f_clk clknet_0_clk clknet_3_6__leaf_clk VDD VDD VSS VSS
+ gf180mcu_fd_sc_mcu7t5v0__clkbuf_16
Xclkbuf_3_7__f_clk clknet_0_clk clknet_3_7__leaf_clk VDD VDD VSS VSS
+ gf180mcu_fd_sc_mcu7t5v0__clkbuf_16
Xclkload0 clknet_3_1__leaf_clk NC_clkload0_ZN VDD VDD VSS VSS gf180mcu_fd_sc_mcu7t5v0__inv_4
Xclkload1 clknet_3_2__leaf_clk NC_clkload1_ZN VDD VDD VSS VSS gf180mcu_fd_sc_mcu7t5v0__clkinv_2
Xclkload2 clknet_3_3__leaf_clk NC_clkload2_ZN VDD VDD VSS VSS gf180mcu_fd_sc_mcu7t5v0__inv_4
Xclkload3 clknet_3_4__leaf_clk NC_clkload3_ZN VDD VDD VSS VSS gf180mcu_fd_sc_mcu7t5v0__inv_4
Xclkload4 clknet_3_5__leaf_clk NC_clkload4_ZN VDD VDD VSS VSS gf180mcu_fd_sc_mcu7t5v0__inv_2
Xclkload5 clknet_3_6__leaf_clk NC_clkload5_ZN VDD VDD VSS VSS gf180mcu_fd_sc_mcu7t5v0__clkinv_8
Xclkload6 clknet_3_7__leaf_clk NC_clkload6_ZN VDD VDD VSS VSS gf180mcu_fd_sc_mcu7t5v0__inv_4
Xinput1 in_cic net1 VDD VDD VSS VSS gf180mcu_fd_sc_mcu7t5v0__dlyb_1
Xinput2 rst net2 VDD VDD VSS VSS gf180mcu_fd_sc_mcu7t5v0__buf_4
Xload_slew15 net16 net15 VDD VDD VSS VSS gf180mcu_fd_sc_mcu7t5v0__buf_8
Xload_slew16 u_clock_div_counter_b7 net16 VDD VDD VSS VSS gf180mcu_fd_sc_mcu7t5v0__buf_8
Xload_slew17 net21 net17 VDD VDD VSS VSS gf180mcu_fd_sc_mcu7t5v0__buf_12
Xload_slew18 net21 net18 VDD VDD VSS VSS gf180mcu_fd_sc_mcu7t5v0__clkbuf_20
Xload_slew19 net21 net19 VDD VDD VSS VSS gf180mcu_fd_sc_mcu7t5v0__buf_12
Xload_slew20 net2 net20 VDD VDD VSS VSS gf180mcu_fd_sc_mcu7t5v0__buf_12
Xload_slew21 net2 net21 VDD VDD VSS VSS gf180mcu_fd_sc_mcu7t5v0__buf_16
Xoutput10 net10 out_cic_b5 VDD VDD VSS VSS gf180mcu_fd_sc_mcu7t5v0__dlyb_1
Xoutput11 net11 out_cic_b6 VDD VDD VSS VSS gf180mcu_fd_sc_mcu7t5v0__dlyb_1
Xoutput12 net12 out_cic_b7 VDD VDD VSS VSS gf180mcu_fd_sc_mcu7t5v0__dlyb_1
Xoutput13 net13 out_cic_b8 VDD VDD VSS VSS gf180mcu_fd_sc_mcu7t5v0__dlyb_1
Xoutput14 net14 out_cic_b9 VDD VDD VSS VSS gf180mcu_fd_sc_mcu7t5v0__dlyb_1
Xoutput3 net3 out_cic_b0 VDD VDD VSS VSS gf180mcu_fd_sc_mcu7t5v0__dlyb_1
Xoutput4 net4 out_cic_b10 VDD VDD VSS VSS gf180mcu_fd_sc_mcu7t5v0__dlyb_1
Xoutput5 net5 out_cic_b11 VDD VDD VSS VSS gf180mcu_fd_sc_mcu7t5v0__dlyb_1
Xoutput6 net6 out_cic_b1 VDD VDD VSS VSS gf180mcu_fd_sc_mcu7t5v0__dlyb_1
Xoutput7 net7 out_cic_b2 VDD VDD VSS VSS gf180mcu_fd_sc_mcu7t5v0__dlyb_1
Xoutput8 net8 out_cic_b3 VDD VDD VSS VSS gf180mcu_fd_sc_mcu7t5v0__dlyb_1
Xoutput9 net9 out_cic_b4 VDD VDD VSS VSS gf180mcu_fd_sc_mcu7t5v0__dlyb_1
.ends

* expanding   symbol:  ./piso_12bit.sym # of pins=18
** sym_path: piso_12bit.sym
** sch_path: piso_12bit.sch
.subckt piso_12bit clk load_en rst_n serial_out VDD VSS data_in_b0 data_in_b1 data_in_b2 data_in_b3
+ data_in_b4 data_in_b5 data_in_b6 data_in_b7 data_in_b8 data_in_b9 data_in_b10 data_in_b11
*.PININFO clk:B load_en:B rst_n:B serial_out:B VDD:B VSS:B data_in_b0:B data_in_b1:B data_in_b2:B
*+ data_in_b3:B data_in_b4:B data_in_b5:B data_in_b6:B data_in_b7:B data_in_b8:B data_in_b9:B data_in_b10:B
*+ data_in_b11:B
XFILLER_0_104 VDD VDD VSS VSS gf180mcu_fd_sc_mcu7t5v0__fill_2
XFILLER_0_106 VDD VDD VSS VSS gf180mcu_fd_sc_mcu7t5v0__fill_1
XFILLER_0_18 VDD VDD VSS VSS gf180mcu_fd_sc_mcu7t5v0__fill_2
XFILLER_0_20 VDD VDD VSS VSS gf180mcu_fd_sc_mcu7t5v0__fill_1
XFILLER_10_104 VDD VDD VSS VSS gf180mcu_fd_sc_mcu7t5v0__fill_2
XFILLER_10_106 VDD VDD VSS VSS gf180mcu_fd_sc_mcu7t5v0__fill_1
XFILLER_10_2 VDD VDD VSS VSS gf180mcu_fd_sc_mcu7t5v0__fillcap_32
XFILLER_10_36 VDD VDD VSS VSS gf180mcu_fd_sc_mcu7t5v0__fillcap_16
XFILLER_10_52 VDD VDD VSS VSS gf180mcu_fd_sc_mcu7t5v0__fillcap_8
XFILLER_1_106 VDD VDD VSS VSS gf180mcu_fd_sc_mcu7t5v0__fill_1
XFILLER_1_18 VDD VDD VSS VSS gf180mcu_fd_sc_mcu7t5v0__fill_2
XFILLER_1_20 VDD VDD VSS VSS gf180mcu_fd_sc_mcu7t5v0__fill_1
XFILLER_1_55 VDD VDD VSS VSS gf180mcu_fd_sc_mcu7t5v0__fill_2
XFILLER_2_18 VDD VDD VSS VSS gf180mcu_fd_sc_mcu7t5v0__fill_1
XFILLER_3_106 VDD VDD VSS VSS gf180mcu_fd_sc_mcu7t5v0__fill_1
XFILLER_4_34 VDD VDD VSS VSS gf180mcu_fd_sc_mcu7t5v0__fill_1
XFILLER_4_37 VDD VDD VSS VSS gf180mcu_fd_sc_mcu7t5v0__fill_2
XFILLER_5_106 VDD VDD VSS VSS gf180mcu_fd_sc_mcu7t5v0__fill_1
XFILLER_5_2 VDD VDD VSS VSS gf180mcu_fd_sc_mcu7t5v0__fill_2
XFILLER_5_69 VDD VDD VSS VSS gf180mcu_fd_sc_mcu7t5v0__fill_1
XFILLER_6_47 VDD VDD VSS VSS gf180mcu_fd_sc_mcu7t5v0__fill_2
XFILLER_6_49 VDD VDD VSS VSS gf180mcu_fd_sc_mcu7t5v0__fill_1
XFILLER_7_106 VDD VDD VSS VSS gf180mcu_fd_sc_mcu7t5v0__fill_1
XFILLER_8_103 VDD VDD VSS VSS gf180mcu_fd_sc_mcu7t5v0__fill_2
XFILLER_8_26 VDD VDD VSS VSS gf180mcu_fd_sc_mcu7t5v0__fill_2
XFILLER_8_28 VDD VDD VSS VSS gf180mcu_fd_sc_mcu7t5v0__fill_1
XFILLER_8_33 VDD VDD VSS VSS gf180mcu_fd_sc_mcu7t5v0__fill_2
XFILLER_8_41 VDD VDD VSS VSS gf180mcu_fd_sc_mcu7t5v0__fillcap_4
XFILLER_8_45 VDD VDD VSS VSS gf180mcu_fd_sc_mcu7t5v0__fill_2
XFILLER_8_47 VDD VDD VSS VSS gf180mcu_fd_sc_mcu7t5v0__fill_1
XFILLER_9_2 VDD VDD VSS VSS gf180mcu_fd_sc_mcu7t5v0__fill_2
XFILLER_9_38 VDD VDD VSS VSS gf180mcu_fd_sc_mcu7t5v0__fillcap_8
XFILLER_9_46 VDD VDD VSS VSS gf180mcu_fd_sc_mcu7t5v0__fillcap_4
XFILLER_9_50 VDD VDD VSS VSS gf180mcu_fd_sc_mcu7t5v0__fill_2
XFILLER_9_60 VDD VDD VSS VSS gf180mcu_fd_sc_mcu7t5v0__fill_1
XFILLER_9_72 VDD VDD VSS VSS gf180mcu_fd_sc_mcu7t5v0__fill_2
XFILLER_9_74 VDD VDD VSS VSS gf180mcu_fd_sc_mcu7t5v0__fill_1
XPHY_EDGE_ROW_0_Left_11 VDD NC_PHY_EDGE_ROW_0_Left_11_VNW NC_PHY_EDGE_ROW_0_Left_11_VPW VSS
+ gf180mcu_fd_sc_mcu7t5v0__endcap
XPHY_EDGE_ROW_0_Right_0 VDD NC_PHY_EDGE_ROW_0_Right_0_VNW NC_PHY_EDGE_ROW_0_Right_0_VPW VSS
+ gf180mcu_fd_sc_mcu7t5v0__endcap
XPHY_EDGE_ROW_10_Left_21 VDD NC_PHY_EDGE_ROW_10_Left_21_VNW NC_PHY_EDGE_ROW_10_Left_21_VPW VSS
+ gf180mcu_fd_sc_mcu7t5v0__endcap
XPHY_EDGE_ROW_10_Right_10 VDD NC_PHY_EDGE_ROW_10_Right_10_VNW NC_PHY_EDGE_ROW_10_Right_10_VPW VSS
+ gf180mcu_fd_sc_mcu7t5v0__endcap
XPHY_EDGE_ROW_1_Left_12 VDD NC_PHY_EDGE_ROW_1_Left_12_VNW NC_PHY_EDGE_ROW_1_Left_12_VPW VSS
+ gf180mcu_fd_sc_mcu7t5v0__endcap
XPHY_EDGE_ROW_1_Right_1 VDD NC_PHY_EDGE_ROW_1_Right_1_VNW NC_PHY_EDGE_ROW_1_Right_1_VPW VSS
+ gf180mcu_fd_sc_mcu7t5v0__endcap
XPHY_EDGE_ROW_2_Left_13 VDD NC_PHY_EDGE_ROW_2_Left_13_VNW NC_PHY_EDGE_ROW_2_Left_13_VPW VSS
+ gf180mcu_fd_sc_mcu7t5v0__endcap
XPHY_EDGE_ROW_2_Right_2 VDD NC_PHY_EDGE_ROW_2_Right_2_VNW NC_PHY_EDGE_ROW_2_Right_2_VPW VSS
+ gf180mcu_fd_sc_mcu7t5v0__endcap
XPHY_EDGE_ROW_3_Left_14 VDD NC_PHY_EDGE_ROW_3_Left_14_VNW NC_PHY_EDGE_ROW_3_Left_14_VPW VSS
+ gf180mcu_fd_sc_mcu7t5v0__endcap
XPHY_EDGE_ROW_3_Right_3 VDD NC_PHY_EDGE_ROW_3_Right_3_VNW NC_PHY_EDGE_ROW_3_Right_3_VPW VSS
+ gf180mcu_fd_sc_mcu7t5v0__endcap
XPHY_EDGE_ROW_4_Left_15 VDD NC_PHY_EDGE_ROW_4_Left_15_VNW NC_PHY_EDGE_ROW_4_Left_15_VPW VSS
+ gf180mcu_fd_sc_mcu7t5v0__endcap
XPHY_EDGE_ROW_4_Right_4 VDD NC_PHY_EDGE_ROW_4_Right_4_VNW NC_PHY_EDGE_ROW_4_Right_4_VPW VSS
+ gf180mcu_fd_sc_mcu7t5v0__endcap
XPHY_EDGE_ROW_5_Left_16 VDD NC_PHY_EDGE_ROW_5_Left_16_VNW NC_PHY_EDGE_ROW_5_Left_16_VPW VSS
+ gf180mcu_fd_sc_mcu7t5v0__endcap
XPHY_EDGE_ROW_5_Right_5 VDD NC_PHY_EDGE_ROW_5_Right_5_VNW NC_PHY_EDGE_ROW_5_Right_5_VPW VSS
+ gf180mcu_fd_sc_mcu7t5v0__endcap
XPHY_EDGE_ROW_6_Left_17 VDD NC_PHY_EDGE_ROW_6_Left_17_VNW NC_PHY_EDGE_ROW_6_Left_17_VPW VSS
+ gf180mcu_fd_sc_mcu7t5v0__endcap
XPHY_EDGE_ROW_6_Right_6 VDD NC_PHY_EDGE_ROW_6_Right_6_VNW NC_PHY_EDGE_ROW_6_Right_6_VPW VSS
+ gf180mcu_fd_sc_mcu7t5v0__endcap
XPHY_EDGE_ROW_7_Left_18 VDD NC_PHY_EDGE_ROW_7_Left_18_VNW NC_PHY_EDGE_ROW_7_Left_18_VPW VSS
+ gf180mcu_fd_sc_mcu7t5v0__endcap
XPHY_EDGE_ROW_7_Right_7 VDD NC_PHY_EDGE_ROW_7_Right_7_VNW NC_PHY_EDGE_ROW_7_Right_7_VPW VSS
+ gf180mcu_fd_sc_mcu7t5v0__endcap
XPHY_EDGE_ROW_8_Left_19 VDD NC_PHY_EDGE_ROW_8_Left_19_VNW NC_PHY_EDGE_ROW_8_Left_19_VPW VSS
+ gf180mcu_fd_sc_mcu7t5v0__endcap
XPHY_EDGE_ROW_8_Right_8 VDD NC_PHY_EDGE_ROW_8_Right_8_VNW NC_PHY_EDGE_ROW_8_Right_8_VPW VSS
+ gf180mcu_fd_sc_mcu7t5v0__endcap
XPHY_EDGE_ROW_9_Left_20 VDD NC_PHY_EDGE_ROW_9_Left_20_VNW NC_PHY_EDGE_ROW_9_Left_20_VPW VSS
+ gf180mcu_fd_sc_mcu7t5v0__endcap
XPHY_EDGE_ROW_9_Right_9 VDD NC_PHY_EDGE_ROW_9_Right_9_VNW NC_PHY_EDGE_ROW_9_Right_9_VPW VSS
+ gf180mcu_fd_sc_mcu7t5v0__endcap
XTAP_TAPCELL_ROW_0_22 VDD VSS gf180mcu_fd_sc_mcu7t5v0__filltie
XTAP_TAPCELL_ROW_0_23 VDD VSS gf180mcu_fd_sc_mcu7t5v0__filltie
XTAP_TAPCELL_ROW_0_24 VDD VSS gf180mcu_fd_sc_mcu7t5v0__filltie
XTAP_TAPCELL_ROW_10_38 VDD VSS gf180mcu_fd_sc_mcu7t5v0__filltie
XTAP_TAPCELL_ROW_10_39 VDD VSS gf180mcu_fd_sc_mcu7t5v0__filltie
XTAP_TAPCELL_ROW_10_40 VDD VSS gf180mcu_fd_sc_mcu7t5v0__filltie
XTAP_TAPCELL_ROW_1_25 VDD VSS gf180mcu_fd_sc_mcu7t5v0__filltie
XTAP_TAPCELL_ROW_2_26 VDD VSS gf180mcu_fd_sc_mcu7t5v0__filltie
XTAP_TAPCELL_ROW_2_27 VDD VSS gf180mcu_fd_sc_mcu7t5v0__filltie
XTAP_TAPCELL_ROW_3_28 VDD VSS gf180mcu_fd_sc_mcu7t5v0__filltie
XTAP_TAPCELL_ROW_4_29 VDD VSS gf180mcu_fd_sc_mcu7t5v0__filltie
XTAP_TAPCELL_ROW_4_30 VDD VSS gf180mcu_fd_sc_mcu7t5v0__filltie
XTAP_TAPCELL_ROW_5_31 VDD VSS gf180mcu_fd_sc_mcu7t5v0__filltie
XTAP_TAPCELL_ROW_6_32 VDD VSS gf180mcu_fd_sc_mcu7t5v0__filltie
XTAP_TAPCELL_ROW_6_33 VDD VSS gf180mcu_fd_sc_mcu7t5v0__filltie
XTAP_TAPCELL_ROW_7_34 VDD VSS gf180mcu_fd_sc_mcu7t5v0__filltie
XTAP_TAPCELL_ROW_8_35 VDD VSS gf180mcu_fd_sc_mcu7t5v0__filltie
XTAP_TAPCELL_ROW_8_36 VDD VSS gf180mcu_fd_sc_mcu7t5v0__filltie
XTAP_TAPCELL_ROW_9_37 VDD VSS gf180mcu_fd_sc_mcu7t5v0__filltie
Xn_34 shift_reg_b0 n_12 VDD VDD VSS VSS gf180mcu_fd_sc_mcu7t5v0__clkinv_1
Xn_35 shift_reg_b1 n_13 VDD VDD VSS VSS gf180mcu_fd_sc_mcu7t5v0__clkinv_1
Xn_36 shift_reg_b2 n_14 VDD VDD VSS VSS gf180mcu_fd_sc_mcu7t5v0__clkinv_1
Xn_37 shift_reg_b3 n_15 VDD VDD VSS VSS gf180mcu_fd_sc_mcu7t5v0__clkinv_1
Xn_38 shift_reg_b4 n_16 VDD VDD VSS VSS gf180mcu_fd_sc_mcu7t5v0__clkinv_1
Xn_39 shift_reg_b5 n_17 VDD VDD VSS VSS gf180mcu_fd_sc_mcu7t5v0__clkinv_1
Xn_40 shift_reg_b6 n_18 VDD VDD VSS VSS gf180mcu_fd_sc_mcu7t5v0__clkinv_1
Xn_41 shift_reg_b7 n_19 VDD VDD VSS VSS gf180mcu_fd_sc_mcu7t5v0__clkinv_1
Xn_42 shift_reg_b8 n_20 VDD VDD VSS VSS gf180mcu_fd_sc_mcu7t5v0__clkinv_1
Xn_43 shift_reg_b9 n_21 VDD VDD VSS VSS gf180mcu_fd_sc_mcu7t5v0__clkinv_1
Xn_44 shift_reg_b10 n_22 VDD VDD VSS VSS gf180mcu_fd_sc_mcu7t5v0__clkinv_1
Xn_45 net4 net13 n_23 VDD VDD VSS VSS gf180mcu_fd_sc_mcu7t5v0__nand2_1
Xn_46 n_12 net13 n_23 n_03 VDD VDD VSS VSS gf180mcu_fd_sc_mcu7t5v0__oai21_1
Xn_47 net13 net5 n_24 VDD VDD VSS VSS gf180mcu_fd_sc_mcu7t5v0__nand2_1
Xn_48 net13 n_13 n_24 n_04 VDD VDD VSS VSS gf180mcu_fd_sc_mcu7t5v0__oai21_1
Xn_49 net13 net6 n_25 VDD VDD VSS VSS gf180mcu_fd_sc_mcu7t5v0__nand2_1
Xn_50 net13 n_14 n_25 n_05 VDD VDD VSS VSS gf180mcu_fd_sc_mcu7t5v0__oai21_1
Xn_51 net13 net7 n_26 VDD VDD VSS VSS gf180mcu_fd_sc_mcu7t5v0__nand2_1
Xn_52 net13 n_15 n_26 n_06 VDD VDD VSS VSS gf180mcu_fd_sc_mcu7t5v0__oai21_1
Xn_53 net13 net8 n_27 VDD VDD VSS VSS gf180mcu_fd_sc_mcu7t5v0__nand2_1
Xn_54 net13 n_16 n_27 n_07 VDD VDD VSS VSS gf180mcu_fd_sc_mcu7t5v0__oai21_1
Xn_55 net13 net9 n_28 VDD VDD VSS VSS gf180mcu_fd_sc_mcu7t5v0__nand2_1
Xn_56 net13 n_17 n_28 n_08 VDD VDD VSS VSS gf180mcu_fd_sc_mcu7t5v0__oai21_1
Xn_57 net13 net10 n_29 VDD VDD VSS VSS gf180mcu_fd_sc_mcu7t5v0__nand2_1
Xn_58 net13 n_18 n_29 n_09 VDD VDD VSS VSS gf180mcu_fd_sc_mcu7t5v0__oai21_1
Xn_59 net13 net11 n_30 VDD VDD VSS VSS gf180mcu_fd_sc_mcu7t5v0__nand2_1
Xn_60 net13 n_19 n_30 n_10 VDD VDD VSS VSS gf180mcu_fd_sc_mcu7t5v0__oai21_1
Xn_61 net13 net12 n_31 VDD VDD VSS VSS gf180mcu_fd_sc_mcu7t5v0__nand2_1
Xn_62 net13 n_20 n_31 n_11 VDD VDD VSS VSS gf180mcu_fd_sc_mcu7t5v0__oai21_1
Xn_63 net13 net2 n_32 VDD VDD VSS VSS gf180mcu_fd_sc_mcu7t5v0__nand2_1
Xn_64 net13 n_21 n_32 n_01 VDD VDD VSS VSS gf180mcu_fd_sc_mcu7t5v0__oai21_1
Xn_65 net13 net3 n_33 VDD VDD VSS VSS gf180mcu_fd_sc_mcu7t5v0__nand2_1
Xn_66 net13 n_22 n_33 n_02 VDD VDD VSS VSS gf180mcu_fd_sc_mcu7t5v0__oai21_1
Xn_67 net13 net1 n_00 VDD VDD VSS VSS gf180mcu_fd_sc_mcu7t5v0__and2_1
Xn_68 n_04 net14 clknet_1_0__leaf_clk shift_reg_b2 VDD VDD VSS VSS gf180mcu_fd_sc_mcu7t5v0__dffrnq_1
Xn_69 n_05 net14 clknet_1_1__leaf_clk shift_reg_b3 VDD VDD VSS VSS gf180mcu_fd_sc_mcu7t5v0__dffrnq_1
Xn_70 n_06 net14 clknet_1_1__leaf_clk shift_reg_b4 VDD VDD VSS VSS gf180mcu_fd_sc_mcu7t5v0__dffrnq_1
Xn_71 n_07 net14 clknet_1_1__leaf_clk shift_reg_b5 VDD VDD VSS VSS gf180mcu_fd_sc_mcu7t5v0__dffrnq_1
Xn_72 n_08 net14 clknet_1_0__leaf_clk shift_reg_b6 VDD VDD VSS VSS gf180mcu_fd_sc_mcu7t5v0__dffrnq_1
Xn_73 n_09 net14 clknet_1_0__leaf_clk shift_reg_b7 VDD VDD VSS VSS gf180mcu_fd_sc_mcu7t5v0__dffrnq_1
Xn_74 n_10 net14 clknet_1_0__leaf_clk shift_reg_b8 VDD VDD VSS VSS gf180mcu_fd_sc_mcu7t5v0__dffrnq_1
Xn_75 n_11 net14 clknet_1_1__leaf_clk shift_reg_b9 VDD VDD VSS VSS gf180mcu_fd_sc_mcu7t5v0__dffrnq_1
Xn_76 n_01 net14 clknet_1_1__leaf_clk shift_reg_b10 VDD VDD VSS VSS
+ gf180mcu_fd_sc_mcu7t5v0__dffrnq_1
Xn_77 n_02 net14 clknet_1_1__leaf_clk net15 VDD VDD VSS VSS gf180mcu_fd_sc_mcu7t5v0__dffrnq_1
Xn_78 n_00 net14 clknet_1_0__leaf_clk shift_reg_b0 VDD VDD VSS VSS gf180mcu_fd_sc_mcu7t5v0__dffrnq_1
Xn_79 n_03 net14 clknet_1_1__leaf_clk shift_reg_b1 VDD VDD VSS VSS gf180mcu_fd_sc_mcu7t5v0__dffrnq_1
Xclkbuf_0_clk clk clknet_0_clk VDD VDD VSS VSS gf180mcu_fd_sc_mcu7t5v0__clkbuf_16
Xclkbuf_1_0__f_clk clknet_0_clk clknet_1_0__leaf_clk VDD VDD VSS VSS
+ gf180mcu_fd_sc_mcu7t5v0__clkbuf_16
Xclkbuf_1_1__f_clk clknet_0_clk clknet_1_1__leaf_clk VDD VDD VSS VSS
+ gf180mcu_fd_sc_mcu7t5v0__clkbuf_16
Xclkload0 clknet_1_0__leaf_clk NC_clkload0_ZN VDD VDD VSS VSS gf180mcu_fd_sc_mcu7t5v0__clkinv_2
Xinput1 data_in_b0 net1 VDD VDD VSS VSS gf180mcu_fd_sc_mcu7t5v0__dlyb_1
Xinput10 data_in_b7 net10 VDD VDD VSS VSS gf180mcu_fd_sc_mcu7t5v0__dlyb_1
Xinput11 data_in_b8 net11 VDD VDD VSS VSS gf180mcu_fd_sc_mcu7t5v0__dlyb_1
Xinput12 data_in_b9 net12 VDD VDD VSS VSS gf180mcu_fd_sc_mcu7t5v0__dlyb_1
Xinput13 load_en net13 VDD VDD VSS VSS gf180mcu_fd_sc_mcu7t5v0__dlyb_1
Xinput14 rst_n net14 VDD VDD VSS VSS gf180mcu_fd_sc_mcu7t5v0__dlyb_1
Xinput2 data_in_b10 net2 VDD VDD VSS VSS gf180mcu_fd_sc_mcu7t5v0__dlyb_1
Xinput3 data_in_b11 net3 VDD VDD VSS VSS gf180mcu_fd_sc_mcu7t5v0__dlyb_1
Xinput4 data_in_b1 net4 VDD VDD VSS VSS gf180mcu_fd_sc_mcu7t5v0__dlyb_1
Xinput5 data_in_b2 net5 VDD VDD VSS VSS gf180mcu_fd_sc_mcu7t5v0__dlyb_1
Xinput6 data_in_b3 net6 VDD VDD VSS VSS gf180mcu_fd_sc_mcu7t5v0__dlyb_1
Xinput7 data_in_b4 net7 VDD VDD VSS VSS gf180mcu_fd_sc_mcu7t5v0__dlyb_1
Xinput8 data_in_b5 net8 VDD VDD VSS VSS gf180mcu_fd_sc_mcu7t5v0__dlyb_1
Xinput9 data_in_b6 net9 VDD VDD VSS VSS gf180mcu_fd_sc_mcu7t5v0__dlyb_1
Xoutput15 net15 serial_out VDD VDD VSS VSS gf180mcu_fd_sc_mcu7t5v0__dlyb_1
.ends

* expanding   symbol:  ./analog_integration_lvs.sym # of pins=14
** sym_path: analog_integration_lvs.sym
** sch_path: analog_integration_lvs.sch
.subckt analog_integration_lvs Vinp Vinn Vop Vom clk1 clk2 Vbiasn Vbiasp clk2B Vout VDD VSS VCM
+ VREFP
*.PININFO Vinp:I Vinn:I Vop:O Vom:O clk1:I clk2:I Vbiasn:I Vbiasp:I clk2B:I Vout:O VDD:B VSS:B VCM:B
*+ VREFP:B
XM1 net1 clk2 OUT_DAC_MIN VSS nfet_03v3 L=0.3u W=1u nf=1 ad='int((nf+1)/2) * W/nf * 0.18u' as='int((nf+2)/2) * W/nf * 0.18u'
+ pd='2*int((nf+1)/2) * (W/nf + 0.18u)' ps='2*int((nf+2)/2) * (W/nf + 0.18u)' nrd='0.18u / W' nrs='0.18u / W'
+ sa=0 sb=0 sd=0
XM2 net2 clk1 VCM VSS nfet_03v3 L=0.3u W=1u nf=1 ad='int((nf+1)/2) * W/nf * 0.18u' as='int((nf+2)/2) * W/nf * 0.18u'
+ pd='2*int((nf+1)/2) * (W/nf + 0.18u)' ps='2*int((nf+2)/2) * (W/nf + 0.18u)' nrd='0.18u / W' nrs='0.18u / W'
+ sa=0 sb=0 sd=0
XM3 Vinp clk1 net1 VSS nfet_03v3 L=0.3u W=1u nf=1 ad='int((nf+1)/2) * W/nf * 0.18u' as='int((nf+2)/2) * W/nf * 0.18u'
+ pd='2*int((nf+1)/2) * (W/nf + 0.18u)' ps='2*int((nf+2)/2) * (W/nf + 0.18u)' nrd='0.18u / W' nrs='0.18u / W'
+ sa=0 sb=0 sd=0
XM4 net2 clk2 Vm VSS nfet_03v3 L=0.3u W=1u nf=1 ad='int((nf+1)/2) * W/nf * 0.18u' as='int((nf+2)/2) * W/nf * 0.18u'
+ pd='2*int((nf+1)/2) * (W/nf + 0.18u)' ps='2*int((nf+2)/2) * (W/nf + 0.18u)' nrd='0.18u / W' nrs='0.18u / W'
+ sa=0 sb=0 sd=0
XM5 net3 clk2 OUT_DAC_PLUS VSS nfet_03v3 L=0.3u W=1u nf=1 ad='int((nf+1)/2) * W/nf * 0.18u' as='int((nf+2)/2) * W/nf * 0.18u'
+ pd='2*int((nf+1)/2) * (W/nf + 0.18u)' ps='2*int((nf+2)/2) * (W/nf + 0.18u)' nrd='0.18u / W' nrs='0.18u / W'
+ sa=0 sb=0 sd=0
XM6 net4 clk1 VCM VSS nfet_03v3 L=0.3u W=1u nf=1 ad='int((nf+1)/2) * W/nf * 0.18u' as='int((nf+2)/2) * W/nf * 0.18u'
+ pd='2*int((nf+1)/2) * (W/nf + 0.18u)' ps='2*int((nf+2)/2) * (W/nf + 0.18u)' nrd='0.18u / W' nrs='0.18u / W'
+ sa=0 sb=0 sd=0
XM7 Vinn clk1 net3 VSS nfet_03v3 L=0.3u W=1u nf=1 ad='int((nf+1)/2) * W/nf * 0.18u' as='int((nf+2)/2) * W/nf * 0.18u'
+ pd='2*int((nf+1)/2) * (W/nf + 0.18u)' ps='2*int((nf+2)/2) * (W/nf + 0.18u)' nrd='0.18u / W' nrs='0.18u / W'
+ sa=0 sb=0 sd=0
XM8 net4 clk2 Vp VSS nfet_03v3 L=0.3u W=1u nf=1 ad='int((nf+1)/2) * W/nf * 0.18u' as='int((nf+2)/2) * W/nf * 0.18u'
+ pd='2*int((nf+1)/2) * (W/nf + 0.18u)' ps='2*int((nf+2)/2) * (W/nf + 0.18u)' nrd='0.18u / W' nrs='0.18u / W'
+ sa=0 sb=0 sd=0
XC1 net2 net1 cap_mim_2f0_m4m5_noshield c_width=10u c_length=10u
XC3 net3 net4 cap_mim_2f0_m4m5_noshield c_width=10u c_length=10u
XC5 Vop Vm cap_mim_2f0_m4m5_noshield c_width=32u c_length=32u
XC6 Vom Vp cap_mim_2f0_m4m5_noshield c_width=32u c_length=32u
x1 VDD Vbiasp Vp Vop Vm Vom Vbiasn VSS fulldiffamp
x2 VDD Vop Vom clk2B Vout VSS ADCv16_verified_comparator
x4 VDD VREFP Vout OUT_DAC_PLUS VSS VSS DAC_1_BIT_PLUS
x3 VDD VSS Vout OUT_DAC_MIN VREFP VSS DAC_1_BIT_MIN
.ends

* expanding   symbol:  ./fulldiffamp.sym # of pins=8
** sym_path: fulldiffamp.sym
** sch_path: fulldiffamp.sch
.subckt fulldiffamp VDD Vbiasp Vp Vop Vm Vom Vbiasn VSS
*.PININFO VDD:B Vbiasp:B Vp:B Vop:B Vm:B Vom:B Vbiasn:B VSS:B
XM5 net2 Vom VDD VDD pfet_03v3 L=2u W=1u nf=1 ad='int((nf+1)/2) * W/nf * 0.18u' as='int((nf+2)/2) * W/nf * 0.18u'
+ pd='2*int((nf+1)/2) * (W/nf + 0.18u)' ps='2*int((nf+2)/2) * (W/nf + 0.18u)' nrd='0.18u / W' nrs='0.18u / W'
+ sa=0 sb=0 sd=0
XM2 Vom Vbiasp VDD VDD pfet_03v3 L=5u W=10u nf=1 ad='int((nf+1)/2) * W/nf * 0.18u' as='int((nf+2)/2) * W/nf * 0.18u'
+ pd='2*int((nf+1)/2) * (W/nf + 0.18u)' ps='2*int((nf+2)/2) * (W/nf + 0.18u)' nrd='0.18u / W' nrs='0.18u / W'
+ sa=0 sb=0 sd=0
XM8 Vom Vm net1 VSS nfet_03v3 L=5u W=10u nf=1 ad='int((nf+1)/2) * W/nf * 0.18u' as='int((nf+2)/2) * W/nf * 0.18u'
+ pd='2*int((nf+1)/2) * (W/nf + 0.18u)' ps='2*int((nf+2)/2) * (W/nf + 0.18u)' nrd='0.18u / W' nrs='0.18u / W'
+ sa=0 sb=0 sd=0
XM7 Vop Vp net1 VSS nfet_03v3 L=5u W=10u nf=1 ad='int((nf+1)/2) * W/nf * 0.18u' as='int((nf+2)/2) * W/nf * 0.18u'
+ pd='2*int((nf+1)/2) * (W/nf + 0.18u)' ps='2*int((nf+2)/2) * (W/nf + 0.18u)' nrd='0.18u / W' nrs='0.18u / W'
+ sa=0 sb=0 sd=0
XM1 Vop Vbiasp VDD VDD pfet_03v3 L=5u W=10u nf=1 ad='int((nf+1)/2) * W/nf * 0.18u' as='int((nf+2)/2) * W/nf * 0.18u'
+ pd='2*int((nf+1)/2) * (W/nf + 0.18u)' ps='2*int((nf+2)/2) * (W/nf + 0.18u)' nrd='0.18u / W' nrs='0.18u / W'
+ sa=0 sb=0 sd=0
XM6 net3 Vop VDD VDD pfet_03v3 L=2u W=1u nf=1 ad='int((nf+1)/2) * W/nf * 0.18u' as='int((nf+2)/2) * W/nf * 0.18u'
+ pd='2*int((nf+1)/2) * (W/nf + 0.18u)' ps='2*int((nf+2)/2) * (W/nf + 0.18u)' nrd='0.18u / W' nrs='0.18u / W'
+ sa=0 sb=0 sd=0
XM4 Vom VDD VDD VDD pfet_03v3 L=5u W=0.5u nf=1 ad='int((nf+1)/2) * W/nf * 0.18u' as='int((nf+2)/2) * W/nf * 0.18u'
+ pd='2*int((nf+1)/2) * (W/nf + 0.18u)' ps='2*int((nf+2)/2) * (W/nf + 0.18u)' nrd='0.18u / W' nrs='0.18u / W'
+ sa=0 sb=0 sd=0
XM3 Vop VDD VDD VDD pfet_03v3 L=5u W=0.5u nf=1 ad='int((nf+1)/2) * W/nf * 0.18u' as='int((nf+2)/2) * W/nf * 0.18u'
+ pd='2*int((nf+1)/2) * (W/nf + 0.18u)' ps='2*int((nf+2)/2) * (W/nf + 0.18u)' nrd='0.18u / W' nrs='0.18u / W'
+ sa=0 sb=0 sd=0
XM9 net1 Vbiasn VSS VSS nfet_03v3 L=2u W=10u nf=1 ad='int((nf+1)/2) * W/nf * 0.18u' as='int((nf+2)/2) * W/nf * 0.18u'
+ pd='2*int((nf+1)/2) * (W/nf + 0.18u)' ps='2*int((nf+2)/2) * (W/nf + 0.18u)' nrd='0.18u / W' nrs='0.18u / W'
+ sa=0 sb=0 sd=0
XM10 net1 Vbiasn VSS VSS nfet_03v3 L=2u W=10u nf=1 ad='int((nf+1)/2) * W/nf * 0.18u' as='int((nf+2)/2) * W/nf * 0.18u'
+ pd='2*int((nf+1)/2) * (W/nf + 0.18u)' ps='2*int((nf+2)/2) * (W/nf + 0.18u)' nrd='0.18u / W' nrs='0.18u / W'
+ sa=0 sb=0 sd=0
XM11 Vop net2 VSS VSS nfet_03v3 L=15u W=0.5u nf=1 ad='int((nf+1)/2) * W/nf * 0.18u' as='int((nf+2)/2) * W/nf * 0.18u'
+ pd='2*int((nf+1)/2) * (W/nf + 0.18u)' ps='2*int((nf+2)/2) * (W/nf + 0.18u)' nrd='0.18u / W' nrs='0.18u / W'
+ sa=0 sb=0 sd=0
XM13 net2 net2 VSS VSS nfet_03v3 L=0.35u W=5u nf=1 ad='int((nf+1)/2) * W/nf * 0.18u' as='int((nf+2)/2) * W/nf * 0.18u'
+ pd='2*int((nf+1)/2) * (W/nf + 0.18u)' ps='2*int((nf+2)/2) * (W/nf + 0.18u)' nrd='0.18u / W' nrs='0.18u / W'
+ sa=0 sb=0 sd=0
XM12 net3 net3 VSS VSS nfet_03v3 L=0.35u W=5u nf=1 ad='int((nf+1)/2) * W/nf * 0.18u' as='int((nf+2)/2) * W/nf * 0.18u'
+ pd='2*int((nf+1)/2) * (W/nf + 0.18u)' ps='2*int((nf+2)/2) * (W/nf + 0.18u)' nrd='0.18u / W' nrs='0.18u / W'
+ sa=0 sb=0 sd=0
XM14 Vom net3 VSS VSS nfet_03v3 L=15u W=0.5u nf=1 ad='int((nf+1)/2) * W/nf * 0.18u' as='int((nf+2)/2) * W/nf * 0.18u'
+ pd='2*int((nf+1)/2) * (W/nf + 0.18u)' ps='2*int((nf+2)/2) * (W/nf + 0.18u)' nrd='0.18u / W' nrs='0.18u / W'
+ sa=0 sb=0 sd=0
.ends

* expanding   symbol:  ./ADCv16_verified_comparator.sym # of pins=6
** sym_path: ADCv16_verified_comparator.sym
** sch_path: ADCv16_verified_comparator.sch
.subckt ADCv16_verified_comparator VDD VIN_C VREF_C CLK VOUT VSS
*.PININFO VDD:B VIN_C:B VREF_C:B CLK:B VOUT:B VSS:B
XM1 net3 VIN_C net1 VDD pfet_03v3 L=0.3u W=5u nf=1 ad='int((nf+1)/2) * W/nf * 0.18u' as='int((nf+2)/2) * W/nf * 0.18u'
+ pd='2*int((nf+1)/2) * (W/nf + 0.18u)' ps='2*int((nf+2)/2) * (W/nf + 0.18u)' nrd='0.18u / W' nrs='0.18u / W'
+ sa=0 sb=0 sd=0
XM2 net5 VREF_C net1 VDD pfet_03v3 L=0.3u W=5u nf=1 ad='int((nf+1)/2) * W/nf * 0.18u' as='int((nf+2)/2) * W/nf * 0.18u'
+ pd='2*int((nf+1)/2) * (W/nf + 0.18u)' ps='2*int((nf+2)/2) * (W/nf + 0.18u)' nrd='0.18u / W' nrs='0.18u / W'
+ sa=0 sb=0 sd=0
XM3 VOUT net2 net5 VDD pfet_03v3 L=0.3u W=5u nf=1 ad='int((nf+1)/2) * W/nf * 0.18u' as='int((nf+2)/2) * W/nf * 0.18u'
+ pd='2*int((nf+1)/2) * (W/nf + 0.18u)' ps='2*int((nf+2)/2) * (W/nf + 0.18u)' nrd='0.18u / W' nrs='0.18u / W'
+ sa=0 sb=0 sd=0
XM4 net4 net2 net3 VDD pfet_03v3 L=0.3u W=5u nf=1 ad='int((nf+1)/2) * W/nf * 0.18u' as='int((nf+2)/2) * W/nf * 0.18u'
+ pd='2*int((nf+1)/2) * (W/nf + 0.18u)' ps='2*int((nf+2)/2) * (W/nf + 0.18u)' nrd='0.18u / W' nrs='0.18u / W'
+ sa=0 sb=0 sd=0
XM6 net2 CLK VDD VDD pfet_03v3 L=0.3u W=5u nf=1 ad='int((nf+1)/2) * W/nf * 0.18u' as='int((nf+2)/2) * W/nf * 0.18u'
+ pd='2*int((nf+1)/2) * (W/nf + 0.18u)' ps='2*int((nf+2)/2) * (W/nf + 0.18u)' nrd='0.18u / W' nrs='0.18u / W'
+ sa=0 sb=0 sd=0
XM7 net2 CLK VSS VSS nfet_03v3 L=0.3u W=2.5u nf=1 ad='int((nf+1)/2) * W/nf * 0.18u' as='int((nf+2)/2) * W/nf * 0.18u'
+ pd='2*int((nf+1)/2) * (W/nf + 0.18u)' ps='2*int((nf+2)/2) * (W/nf + 0.18u)' nrd='0.18u / W' nrs='0.18u / W'
+ sa=0 sb=0 sd=0
XM8 net4 CLK VOUT VSS nfet_03v3 L=0.3u W=2.5u nf=1 ad='int((nf+1)/2) * W/nf * 0.18u' as='int((nf+2)/2) * W/nf * 0.18u'
+ pd='2*int((nf+1)/2) * (W/nf + 0.18u)' ps='2*int((nf+2)/2) * (W/nf + 0.18u)' nrd='0.18u / W' nrs='0.18u / W'
+ sa=0 sb=0 sd=0
XM9 net7 VOUT VDD VDD pfet_03v3 L=0.3u W=5u nf=1 ad='int((nf+1)/2) * W/nf * 0.18u' as='int((nf+2)/2) * W/nf * 0.18u'
+ pd='2*int((nf+1)/2) * (W/nf + 0.18u)' ps='2*int((nf+2)/2) * (W/nf + 0.18u)' nrd='0.18u / W' nrs='0.18u / W'
+ sa=0 sb=0 sd=0
XM10 net4 CLK net7 VDD pfet_03v3 L=0.3u W=5u nf=1 ad='int((nf+1)/2) * W/nf * 0.18u' as='int((nf+2)/2) * W/nf * 0.18u'
+ pd='2*int((nf+1)/2) * (W/nf + 0.18u)' ps='2*int((nf+2)/2) * (W/nf + 0.18u)' nrd='0.18u / W' nrs='0.18u / W'
+ sa=0 sb=0 sd=0
XM11 net4 VOUT VSS VSS nfet_03v3 L=0.3u W=2.5u nf=1 ad='int((nf+1)/2) * W/nf * 0.18u' as='int((nf+2)/2) * W/nf * 0.18u'
+ pd='2*int((nf+1)/2) * (W/nf + 0.18u)' ps='2*int((nf+2)/2) * (W/nf + 0.18u)' nrd='0.18u / W' nrs='0.18u / W'
+ sa=0 sb=0 sd=0
XM12 net6 net4 VDD VDD pfet_03v3 L=0.3u W=5u nf=1 ad='int((nf+1)/2) * W/nf * 0.18u' as='int((nf+2)/2) * W/nf * 0.18u'
+ pd='2*int((nf+1)/2) * (W/nf + 0.18u)' ps='2*int((nf+2)/2) * (W/nf + 0.18u)' nrd='0.18u / W' nrs='0.18u / W'
+ sa=0 sb=0 sd=0
XM13 VOUT CLK net6 VDD pfet_03v3 L=0.3u W=5u nf=1 ad='int((nf+1)/2) * W/nf * 0.18u' as='int((nf+2)/2) * W/nf * 0.18u'
+ pd='2*int((nf+1)/2) * (W/nf + 0.18u)' ps='2*int((nf+2)/2) * (W/nf + 0.18u)' nrd='0.18u / W' nrs='0.18u / W'
+ sa=0 sb=0 sd=0
XM14 VOUT net4 VSS VSS nfet_03v3 L=0.3u W=2.5u nf=1 ad='int((nf+1)/2) * W/nf * 0.18u' as='int((nf+2)/2) * W/nf * 0.18u'
+ pd='2*int((nf+1)/2) * (W/nf + 0.18u)' ps='2*int((nf+2)/2) * (W/nf + 0.18u)' nrd='0.18u / W' nrs='0.18u / W'
+ sa=0 sb=0 sd=0
XM5 net1 VSS VDD VDD pfet_03v3 L=0.3u W=10u nf=1 ad='int((nf+1)/2) * W/nf * 0.18u' as='int((nf+2)/2) * W/nf * 0.18u'
+ pd='2*int((nf+1)/2) * (W/nf + 0.18u)' ps='2*int((nf+2)/2) * (W/nf + 0.18u)' nrd='0.18u / W' nrs='0.18u / W'
+ sa=0 sb=0 sd=0
.ends

* expanding   symbol:  ./DAC_1_BIT_PLUS.sym # of pins=6
** sym_path: DAC_1_BIT_PLUS.sym
** sch_path: DAC_1_BIT_PLUS.sch
.subckt DAC_1_BIT_PLUS VDD VREF+ VIN VOUT VREF- VSS
*.PININFO VDD:B VREF+:B VIN:B VOUT:B VREF-:B VSS:B
XM1 net1 net2 VREF+ VSS nfet_03v3 L=Ld W=Wdn_p nf=2 ad='int((nf+1)/2) * W/nf * 0.18u' as='int((nf+2)/2) * W/nf * 0.18u'
+ pd='2*int((nf+1)/2) * (W/nf + 0.18u)' ps='2*int((nf+2)/2) * (W/nf + 0.18u)' nrd='0.18u / W' nrs='0.18u / W'
+ sa=0 sb=0 sd=0
XM2 net1 VIN VREF+ VDD pfet_03v3 L=Ld W=Wdp_p nf=2 ad='int((nf+1)/2) * W/nf * 0.18u' as='int((nf+2)/2) * W/nf * 0.18u'
+ pd='2*int((nf+1)/2) * (W/nf + 0.18u)' ps='2*int((nf+2)/2) * (W/nf + 0.18u)' nrd='0.18u / W' nrs='0.18u / W'
+ sa=0 sb=0 sd=0
XM3 net1 VIN VREF- VSS nfet_03v3 L=Ld W=Wdn_p nf=2 ad='int((nf+1)/2) * W/nf * 0.18u' as='int((nf+2)/2) * W/nf * 0.18u'
+ pd='2*int((nf+1)/2) * (W/nf + 0.18u)' ps='2*int((nf+2)/2) * (W/nf + 0.18u)' nrd='0.18u / W' nrs='0.18u / W'
+ sa=0 sb=0 sd=0
XM4 net1 net2 VREF- VDD pfet_03v3 L=Ld W=Wdp_p nf=2 ad='int((nf+1)/2) * W/nf * 0.18u' as='int((nf+2)/2) * W/nf * 0.18u'
+ pd='2*int((nf+1)/2) * (W/nf + 0.18u)' ps='2*int((nf+2)/2) * (W/nf + 0.18u)' nrd='0.18u / W' nrs='0.18u / W'
+ sa=0 sb=0 sd=0
XM5 net2 VIN VDD VDD pfet_03v3 L=Ld W=Wsp_p nf=1 ad='int((nf+1)/2) * W/nf * 0.18u' as='int((nf+2)/2) * W/nf * 0.18u'
+ pd='2*int((nf+1)/2) * (W/nf + 0.18u)' ps='2*int((nf+2)/2) * (W/nf + 0.18u)' nrd='0.18u / W' nrs='0.18u / W'
+ sa=0 sb=0 sd=0
XM6 net2 VIN VSS VSS nfet_03v3 L=Ld W=Wsn_p nf=1 ad='int((nf+1)/2) * W/nf * 0.18u' as='int((nf+2)/2) * W/nf * 0.18u'
+ pd='2*int((nf+1)/2) * (W/nf + 0.18u)' ps='2*int((nf+2)/2) * (W/nf + 0.18u)' nrd='0.18u / W' nrs='0.18u / W'
+ sa=0 sb=0 sd=0
XM7 net3 net1 VDD VDD pfet_03v3 L=Ld W=Wsp_p nf=1 ad='int((nf+1)/2) * W/nf * 0.18u' as='int((nf+2)/2) * W/nf * 0.18u'
+ pd='2*int((nf+1)/2) * (W/nf + 0.18u)' ps='2*int((nf+2)/2) * (W/nf + 0.18u)' nrd='0.18u / W' nrs='0.18u / W'
+ sa=0 sb=0 sd=0
XM8 net3 net1 VSS VSS nfet_03v3 L=Ld W=Wsn_p nf=1 ad='int((nf+1)/2) * W/nf * 0.18u' as='int((nf+2)/2) * W/nf * 0.18u'
+ pd='2*int((nf+1)/2) * (W/nf + 0.18u)' ps='2*int((nf+2)/2) * (W/nf + 0.18u)' nrd='0.18u / W' nrs='0.18u / W'
+ sa=0 sb=0 sd=0
XM9 VOUT net3 VDD VDD pfet_03v3 L=Ld W=Wsp2_p nf=1 ad='int((nf+1)/2) * W/nf * 0.18u' as='int((nf+2)/2) * W/nf * 0.18u'
+ pd='2*int((nf+1)/2) * (W/nf + 0.18u)' ps='2*int((nf+2)/2) * (W/nf + 0.18u)' nrd='0.18u / W' nrs='0.18u / W'
+ sa=0 sb=0 sd=0
XM10 VOUT net3 VSS VSS nfet_03v3 L=Ld W=Wsn2_p nf=1 ad='int((nf+1)/2) * W/nf * 0.18u' as='int((nf+2)/2) * W/nf * 0.18u'
+ pd='2*int((nf+1)/2) * (W/nf + 0.18u)' ps='2*int((nf+2)/2) * (W/nf + 0.18u)' nrd='0.18u / W' nrs='0.18u / W'
+ sa=0 sb=0 sd=0
.ends

* expanding   symbol:  ./DAC_1_BIT_MIN.sym # of pins=6
** sym_path: DAC_1_BIT_MIN.sym
** sch_path: DAC_1_BIT_MIN.sch
.subckt DAC_1_BIT_MIN VDD VREF+ VIN VOUT VREF- VSS
*.PININFO VDD:B VREF+:B VIN:B VOUT:B VREF-:B VSS:B
XM1 net1 net2 VREF+ VSS nfet_03v3 L=0.28u W=1u nf=2 ad='int((nf+1)/2) * W/nf * 0.18u' as='int((nf+2)/2) * W/nf * 0.18u'
+ pd='2*int((nf+1)/2) * (W/nf + 0.18u)' ps='2*int((nf+2)/2) * (W/nf + 0.18u)' nrd='0.18u / W' nrs='0.18u / W'
+ sa=0 sb=0 sd=0
XM2 net1 VIN VREF+ VDD pfet_03v3 L=0.28u W=10u nf=2 ad='int((nf+1)/2) * W/nf * 0.18u' as='int((nf+2)/2) * W/nf * 0.18u'
+ pd='2*int((nf+1)/2) * (W/nf + 0.18u)' ps='2*int((nf+2)/2) * (W/nf + 0.18u)' nrd='0.18u / W' nrs='0.18u / W'
+ sa=0 sb=0 sd=0
XM3 net1 VIN VREF- VSS nfet_03v3 L=0.28u W=1u nf=2 ad='int((nf+1)/2) * W/nf * 0.18u' as='int((nf+2)/2) * W/nf * 0.18u'
+ pd='2*int((nf+1)/2) * (W/nf + 0.18u)' ps='2*int((nf+2)/2) * (W/nf + 0.18u)' nrd='0.18u / W' nrs='0.18u / W'
+ sa=0 sb=0 sd=0
XM4 net1 net2 VREF- VDD pfet_03v3 L=0.28u W=10u nf=2 ad='int((nf+1)/2) * W/nf * 0.18u' as='int((nf+2)/2) * W/nf * 0.18u'
+ pd='2*int((nf+1)/2) * (W/nf + 0.18u)' ps='2*int((nf+2)/2) * (W/nf + 0.18u)' nrd='0.18u / W' nrs='0.18u / W'
+ sa=0 sb=0 sd=0
XM5 net2 VIN VDD VDD pfet_03v3 L=0.28u W=5u nf=1 ad='int((nf+1)/2) * W/nf * 0.18u' as='int((nf+2)/2) * W/nf * 0.18u'
+ pd='2*int((nf+1)/2) * (W/nf + 0.18u)' ps='2*int((nf+2)/2) * (W/nf + 0.18u)' nrd='0.18u / W' nrs='0.18u / W'
+ sa=0 sb=0 sd=0
XM6 net2 VIN VSS VSS nfet_03v3 L=0.28u W=0.5u nf=1 ad='int((nf+1)/2) * W/nf * 0.18u' as='int((nf+2)/2) * W/nf * 0.18u'
+ pd='2*int((nf+1)/2) * (W/nf + 0.18u)' ps='2*int((nf+2)/2) * (W/nf + 0.18u)' nrd='0.18u / W' nrs='0.18u / W'
+ sa=0 sb=0 sd=0
XM7 VOUT net1 VDD VDD pfet_03v3 L=0.28u W=5u nf=1 ad='int((nf+1)/2) * W/nf * 0.18u' as='int((nf+2)/2) * W/nf * 0.18u'
+ pd='2*int((nf+1)/2) * (W/nf + 0.18u)' ps='2*int((nf+2)/2) * (W/nf + 0.18u)' nrd='0.18u / W' nrs='0.18u / W'
+ sa=0 sb=0 sd=0
XM8 VOUT net1 VSS VSS nfet_03v3 L=0.28u W=0.5u nf=1 ad='int((nf+1)/2) * W/nf * 0.18u' as='int((nf+2)/2) * W/nf * 0.18u'
+ pd='2*int((nf+1)/2) * (W/nf + 0.18u)' ps='2*int((nf+2)/2) * (W/nf + 0.18u)' nrd='0.18u / W' nrs='0.18u / W'
+ sa=0 sb=0 sd=0
.ends

**** begin user architecture code

.include ADC_v16_support.spice

**** end user architecture code
.end
